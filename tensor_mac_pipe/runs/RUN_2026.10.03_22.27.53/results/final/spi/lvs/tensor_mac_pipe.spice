* NGSPICE file created from tensor_mac_pipe.ext - technology: sky130A

* Black-box entry subcircuit for sky130_fd_sc_hd__tapvpwrvgnd_1 abstract view
.subckt sky130_fd_sc_hd__tapvpwrvgnd_1 VGND VPWR
.ends

* Black-box entry subcircuit for sky130_ef_sc_hd__decap_12 abstract view
.subckt sky130_ef_sc_hd__decap_12 VPWR VGND VPB VNB
.ends

* Black-box entry subcircuit for sky130_fd_sc_hd__decap_6 abstract view
.subckt sky130_fd_sc_hd__decap_6 VGND VNB VPB VPWR
.ends

* Black-box entry subcircuit for sky130_fd_sc_hd__fill_1 abstract view
.subckt sky130_fd_sc_hd__fill_1 VGND VNB VPB VPWR
.ends

* Black-box entry subcircuit for sky130_fd_sc_hd__nand2_1 abstract view
.subckt sky130_fd_sc_hd__nand2_1 A B VGND VNB VPB VPWR Y
.ends

* Black-box entry subcircuit for sky130_fd_sc_hd__clkbuf_1 abstract view
.subckt sky130_fd_sc_hd__clkbuf_1 A VGND VNB VPB VPWR X
.ends

* Black-box entry subcircuit for sky130_fd_sc_hd__fill_2 abstract view
.subckt sky130_fd_sc_hd__fill_2 VGND VNB VPB VPWR
.ends

* Black-box entry subcircuit for sky130_fd_sc_hd__decap_4 abstract view
.subckt sky130_fd_sc_hd__decap_4 VGND VNB VPB VPWR
.ends

* Black-box entry subcircuit for sky130_fd_sc_hd__dfrtp_4 abstract view
.subckt sky130_fd_sc_hd__dfrtp_4 CLK D RESET_B VGND VNB VPB VPWR Q
.ends

* Black-box entry subcircuit for sky130_fd_sc_hd__decap_8 abstract view
.subckt sky130_fd_sc_hd__decap_8 VGND VNB VPB VPWR
.ends

* Black-box entry subcircuit for sky130_fd_sc_hd__and3_1 abstract view
.subckt sky130_fd_sc_hd__and3_1 A B C VGND VNB VPB VPWR X
.ends

* Black-box entry subcircuit for sky130_fd_sc_hd__inv_2 abstract view
.subckt sky130_fd_sc_hd__inv_2 A VGND VNB VPB VPWR Y
.ends

* Black-box entry subcircuit for sky130_fd_sc_hd__o21a_1 abstract view
.subckt sky130_fd_sc_hd__o21a_1 A1 A2 B1 VGND VNB VPB VPWR X
.ends

* Black-box entry subcircuit for sky130_fd_sc_hd__decap_3 abstract view
.subckt sky130_fd_sc_hd__decap_3 VGND VNB VPB VPWR
.ends

* Black-box entry subcircuit for sky130_fd_sc_hd__a21oi_1 abstract view
.subckt sky130_fd_sc_hd__a21oi_1 A1 A2 B1 VGND VNB VPB VPWR Y
.ends

* Black-box entry subcircuit for sky130_fd_sc_hd__a21oi_2 abstract view
.subckt sky130_fd_sc_hd__a21oi_2 A1 A2 B1 VGND VNB VPB VPWR Y
.ends

* Black-box entry subcircuit for sky130_fd_sc_hd__clkbuf_4 abstract view
.subckt sky130_fd_sc_hd__clkbuf_4 A VGND VNB VPB VPWR X
.ends

* Black-box entry subcircuit for sky130_fd_sc_hd__nor3_1 abstract view
.subckt sky130_fd_sc_hd__nor3_1 A B C VGND VNB VPB VPWR Y
.ends

* Black-box entry subcircuit for sky130_fd_sc_hd__a22oi_1 abstract view
.subckt sky130_fd_sc_hd__a22oi_1 A1 A2 B1 B2 VGND VNB VPB VPWR Y
.ends

* Black-box entry subcircuit for sky130_fd_sc_hd__and4_1 abstract view
.subckt sky130_fd_sc_hd__and4_1 A B C D VGND VNB VPB VPWR X
.ends

* Black-box entry subcircuit for sky130_fd_sc_hd__nor2_1 abstract view
.subckt sky130_fd_sc_hd__nor2_1 A B VGND VNB VPB VPWR Y
.ends

* Black-box entry subcircuit for sky130_fd_sc_hd__a211o_1 abstract view
.subckt sky130_fd_sc_hd__a211o_1 A1 A2 B1 C1 VGND VNB VPB VPWR X
.ends

* Black-box entry subcircuit for sky130_fd_sc_hd__dfrtp_1 abstract view
.subckt sky130_fd_sc_hd__dfrtp_1 CLK D RESET_B VGND VNB VPB VPWR Q
.ends

* Black-box entry subcircuit for sky130_fd_sc_hd__xnor2_1 abstract view
.subckt sky130_fd_sc_hd__xnor2_1 A B VGND VNB VPB VPWR Y
.ends

* Black-box entry subcircuit for sky130_fd_sc_hd__and2_1 abstract view
.subckt sky130_fd_sc_hd__and2_1 A B VGND VNB VPB VPWR X
.ends

* Black-box entry subcircuit for sky130_fd_sc_hd__o211ai_4 abstract view
.subckt sky130_fd_sc_hd__o211ai_4 A1 A2 B1 C1 VGND VNB VPB VPWR Y
.ends

* Black-box entry subcircuit for sky130_fd_sc_hd__o21ai_1 abstract view
.subckt sky130_fd_sc_hd__o21ai_1 A1 A2 B1 VGND VNB VPB VPWR Y
.ends

* Black-box entry subcircuit for sky130_fd_sc_hd__xor2_1 abstract view
.subckt sky130_fd_sc_hd__xor2_1 A B VGND VNB VPB VPWR X
.ends

* Black-box entry subcircuit for sky130_fd_sc_hd__a21o_1 abstract view
.subckt sky130_fd_sc_hd__a21o_1 A1 A2 B1 VGND VNB VPB VPWR X
.ends

* Black-box entry subcircuit for sky130_fd_sc_hd__or3b_1 abstract view
.subckt sky130_fd_sc_hd__or3b_1 A B C_N VGND VNB VPB VPWR X
.ends

* Black-box entry subcircuit for sky130_fd_sc_hd__or2b_1 abstract view
.subckt sky130_fd_sc_hd__or2b_1 A B_N VGND VNB VPB VPWR X
.ends

* Black-box entry subcircuit for sky130_fd_sc_hd__buf_4 abstract view
.subckt sky130_fd_sc_hd__buf_4 A VGND VNB VPB VPWR X
.ends

* Black-box entry subcircuit for sky130_fd_sc_hd__and2b_1 abstract view
.subckt sky130_fd_sc_hd__and2b_1 A_N B VGND VNB VPB VPWR X
.ends

* Black-box entry subcircuit for sky130_fd_sc_hd__a22o_1 abstract view
.subckt sky130_fd_sc_hd__a22o_1 A1 A2 B1 B2 VGND VNB VPB VPWR X
.ends

* Black-box entry subcircuit for sky130_fd_sc_hd__nand3_2 abstract view
.subckt sky130_fd_sc_hd__nand3_2 A B C VGND VNB VPB VPWR Y
.ends

* Black-box entry subcircuit for sky130_fd_sc_hd__o22a_1 abstract view
.subckt sky130_fd_sc_hd__o22a_1 A1 A2 B1 B2 VGND VNB VPB VPWR X
.ends

* Black-box entry subcircuit for sky130_fd_sc_hd__dlygate4sd3_1 abstract view
.subckt sky130_fd_sc_hd__dlygate4sd3_1 A VGND VNB VPB VPWR X
.ends

* Black-box entry subcircuit for sky130_fd_sc_hd__o32a_1 abstract view
.subckt sky130_fd_sc_hd__o32a_1 A1 A2 A3 B1 B2 VGND VNB VPB VPWR X
.ends

* Black-box entry subcircuit for sky130_fd_sc_hd__or2_1 abstract view
.subckt sky130_fd_sc_hd__or2_1 A B VGND VNB VPB VPWR X
.ends

* Black-box entry subcircuit for sky130_fd_sc_hd__nor4_4 abstract view
.subckt sky130_fd_sc_hd__nor4_4 A B C D VGND VNB VPB VPWR Y
.ends

* Black-box entry subcircuit for sky130_fd_sc_hd__buf_2 abstract view
.subckt sky130_fd_sc_hd__buf_2 A VGND VNB VPB VPWR X
.ends

* Black-box entry subcircuit for sky130_fd_sc_hd__mux2_1 abstract view
.subckt sky130_fd_sc_hd__mux2_1 A0 A1 S VGND VNB VPB VPWR X
.ends

* Black-box entry subcircuit for sky130_fd_sc_hd__a211oi_2 abstract view
.subckt sky130_fd_sc_hd__a211oi_2 A1 A2 B1 C1 VGND VNB VPB VPWR Y
.ends

* Black-box entry subcircuit for sky130_fd_sc_hd__nand4_2 abstract view
.subckt sky130_fd_sc_hd__nand4_2 A B C D VGND VNB VPB VPWR Y
.ends

* Black-box entry subcircuit for sky130_fd_sc_hd__clkbuf_16 abstract view
.subckt sky130_fd_sc_hd__clkbuf_16 A VGND VNB VPB VPWR X
.ends

* Black-box entry subcircuit for sky130_fd_sc_hd__o211a_4 abstract view
.subckt sky130_fd_sc_hd__o211a_4 A1 A2 B1 C1 VGND VNB VPB VPWR X
.ends

* Black-box entry subcircuit for sky130_fd_sc_hd__buf_6 abstract view
.subckt sky130_fd_sc_hd__buf_6 A VGND VNB VPB VPWR X
.ends

* Black-box entry subcircuit for sky130_fd_sc_hd__or3_4 abstract view
.subckt sky130_fd_sc_hd__or3_4 A B C VGND VNB VPB VPWR X
.ends

* Black-box entry subcircuit for sky130_fd_sc_hd__clkbuf_8 abstract view
.subckt sky130_fd_sc_hd__clkbuf_8 A VGND VNB VPB VPWR X
.ends

* Black-box entry subcircuit for sky130_fd_sc_hd__o211a_1 abstract view
.subckt sky130_fd_sc_hd__o211a_1 A1 A2 B1 C1 VGND VNB VPB VPWR X
.ends

* Black-box entry subcircuit for sky130_fd_sc_hd__a21bo_1 abstract view
.subckt sky130_fd_sc_hd__a21bo_1 A1 A2 B1_N VGND VNB VPB VPWR X
.ends

* Black-box entry subcircuit for sky130_fd_sc_hd__nand3_1 abstract view
.subckt sky130_fd_sc_hd__nand3_1 A B C VGND VNB VPB VPWR Y
.ends

* Black-box entry subcircuit for sky130_fd_sc_hd__a31o_1 abstract view
.subckt sky130_fd_sc_hd__a31o_1 A1 A2 A3 B1 VGND VNB VPB VPWR X
.ends

* Black-box entry subcircuit for sky130_fd_sc_hd__and3b_1 abstract view
.subckt sky130_fd_sc_hd__and3b_1 A_N B C VGND VNB VPB VPWR X
.ends

* Black-box entry subcircuit for sky130_fd_sc_hd__and3_4 abstract view
.subckt sky130_fd_sc_hd__and3_4 A B C VGND VNB VPB VPWR X
.ends

* Black-box entry subcircuit for sky130_fd_sc_hd__or3_1 abstract view
.subckt sky130_fd_sc_hd__or3_1 A B C VGND VNB VPB VPWR X
.ends

* Black-box entry subcircuit for sky130_fd_sc_hd__dfrtp_2 abstract view
.subckt sky130_fd_sc_hd__dfrtp_2 CLK D RESET_B VGND VNB VPB VPWR Q
.ends

* Black-box entry subcircuit for sky130_fd_sc_hd__clkbuf_2 abstract view
.subckt sky130_fd_sc_hd__clkbuf_2 A VGND VNB VPB VPWR X
.ends

* Black-box entry subcircuit for sky130_fd_sc_hd__a211oi_1 abstract view
.subckt sky130_fd_sc_hd__a211oi_1 A1 A2 B1 C1 VGND VNB VPB VPWR Y
.ends

* Black-box entry subcircuit for sky130_fd_sc_hd__buf_1 abstract view
.subckt sky130_fd_sc_hd__buf_1 A VGND VNB VPB VPWR X
.ends

* Black-box entry subcircuit for sky130_fd_sc_hd__o21ba_1 abstract view
.subckt sky130_fd_sc_hd__o21ba_1 A1 A2 B1_N VGND VNB VPB VPWR X
.ends

* Black-box entry subcircuit for sky130_fd_sc_hd__buf_8 abstract view
.subckt sky130_fd_sc_hd__buf_8 A VGND VNB VPB VPWR X
.ends

* Black-box entry subcircuit for sky130_fd_sc_hd__a21boi_1 abstract view
.subckt sky130_fd_sc_hd__a21boi_1 A1 A2 B1_N VGND VNB VPB VPWR Y
.ends

* Black-box entry subcircuit for sky130_fd_sc_hd__nor2_2 abstract view
.subckt sky130_fd_sc_hd__nor2_2 A B VGND VNB VPB VPWR Y
.ends

* Black-box entry subcircuit for sky130_fd_sc_hd__nor2b_1 abstract view
.subckt sky130_fd_sc_hd__nor2b_1 A B_N VGND VNB VPB VPWR Y
.ends

* Black-box entry subcircuit for sky130_fd_sc_hd__a31oi_2 abstract view
.subckt sky130_fd_sc_hd__a31oi_2 A1 A2 A3 B1 VGND VNB VPB VPWR Y
.ends

* Black-box entry subcircuit for sky130_fd_sc_hd__nand4_1 abstract view
.subckt sky130_fd_sc_hd__nand4_1 A B C D VGND VNB VPB VPWR Y
.ends

* Black-box entry subcircuit for sky130_fd_sc_hd__a31oi_4 abstract view
.subckt sky130_fd_sc_hd__a31oi_4 A1 A2 A3 B1 VGND VNB VPB VPWR Y
.ends

* Black-box entry subcircuit for sky130_fd_sc_hd__o211ai_2 abstract view
.subckt sky130_fd_sc_hd__o211ai_2 A1 A2 B1 C1 VGND VNB VPB VPWR Y
.ends

* Black-box entry subcircuit for sky130_fd_sc_hd__or4_1 abstract view
.subckt sky130_fd_sc_hd__or4_1 A B C D VGND VNB VPB VPWR X
.ends

* Black-box entry subcircuit for sky130_fd_sc_hd__o21bai_1 abstract view
.subckt sky130_fd_sc_hd__o21bai_1 A1 A2 B1_N VGND VNB VPB VPWR Y
.ends

* Black-box entry subcircuit for sky130_fd_sc_hd__or2_4 abstract view
.subckt sky130_fd_sc_hd__or2_4 A B VGND VNB VPB VPWR X
.ends

* Black-box entry subcircuit for sky130_fd_sc_hd__xor2_2 abstract view
.subckt sky130_fd_sc_hd__xor2_2 A B VGND VNB VPB VPWR X
.ends

* Black-box entry subcircuit for sky130_fd_sc_hd__o2bb2ai_1 abstract view
.subckt sky130_fd_sc_hd__o2bb2ai_1 A1_N A2_N B1 B2 VGND VNB VPB VPWR Y
.ends

* Black-box entry subcircuit for sky130_fd_sc_hd__diode_2 abstract view
.subckt sky130_fd_sc_hd__diode_2 DIODE VGND VNB VPB VPWR
.ends

* Black-box entry subcircuit for sky130_fd_sc_hd__o22ai_2 abstract view
.subckt sky130_fd_sc_hd__o22ai_2 A1 A2 B1 B2 VGND VNB VPB VPWR Y
.ends

.subckt tensor_mac_pipe VGND VPWR accumulator[0] accumulator[10] accumulator[11] accumulator[12]
+ accumulator[13] accumulator[14] accumulator[15] accumulator[1] accumulator[2] accumulator[3]
+ accumulator[4] accumulator[5] accumulator[6] accumulator[7] accumulator[8] accumulator[9]
+ activation[0] activation[1] activation[2] activation[3] activation[4] activation[5]
+ activation[6] activation[7] clk reset weight[0] weight[1] weight[2] weight[3] weight[4]
+ weight[5] weight[6] weight[7]
XTAP_177 VGND VPWR sky130_fd_sc_hd__tapvpwrvgnd_1
XTAP_188 VGND VPWR sky130_fd_sc_hd__tapvpwrvgnd_1
XTAP_199 VGND VPWR sky130_fd_sc_hd__tapvpwrvgnd_1
XFILLER_0_43_81 VPWR VGND VPWR VGND sky130_ef_sc_hd__decap_12
XFILLER_0_17_200 VGND VGND VPWR VPWR sky130_fd_sc_hd__decap_6
XFILLER_0_17_244 VPWR VGND VPWR VGND sky130_ef_sc_hd__decap_12
XFILLER_0_32_269 VGND VGND VPWR VPWR sky130_fd_sc_hd__fill_1
XFILLER_0_7_81 VPWR VGND VPWR VGND sky130_ef_sc_hd__decap_12
X_501_ _079_ net6 VGND VGND VPWR VPWR _120_ sky130_fd_sc_hd__nand2_1
XFILLER_0_23_225 VPWR VGND VPWR VGND sky130_ef_sc_hd__decap_12
Xrebuffer7 _206_ VGND VGND VPWR VPWR net40 sky130_fd_sc_hd__clkbuf_1
XFILLER_0_3_39 VPWR VGND VPWR VGND sky130_ef_sc_hd__decap_12
XFILLER_0_14_203 VGND VGND VPWR VPWR sky130_fd_sc_hd__fill_2
XFILLER_0_46_125 VGND VGND VPWR VPWR sky130_fd_sc_hd__decap_4
XFILLER_0_6_277 VPWR VGND VPWR VGND sky130_ef_sc_hd__decap_12
XFILLER_0_6_233 VPWR VGND VPWR VGND sky130_ef_sc_hd__decap_12
XFILLER_0_37_169 VGND VGND VPWR VPWR sky130_fd_sc_hd__fill_2
X_895_ clknet_2_3__leaf_clk _013_ _039_ VGND VGND VPWR VPWR net31 sky130_fd_sc_hd__dfrtp_4
XFILLER_0_45_27 VPWR VGND VPWR VGND sky130_ef_sc_hd__decap_12
XFILLER_0_0_29 VPWR VGND VPWR VGND sky130_ef_sc_hd__decap_12
XFILLER_0_3_225 VPWR VGND VPWR VGND sky130_ef_sc_hd__decap_12
XFILLER_0_10_41 VPWR VGND VPWR VGND sky130_ef_sc_hd__decap_12
XFILLER_0_35_93 VGND VGND VPWR VPWR sky130_fd_sc_hd__decap_8
XFILLER_0_35_60 VPWR VGND VPWR VGND sky130_ef_sc_hd__decap_12
XFILLER_0_34_139 VGND VGND VPWR VPWR sky130_fd_sc_hd__fill_1
X_680_ _085_ _188_ _293_ VGND VGND VPWR VPWR _294_ sky130_fd_sc_hd__and3_1
XFILLER_0_40_109 VPWR VGND VPWR VGND sky130_ef_sc_hd__decap_12
XFILLER_0_18_191 VGND VGND VPWR VPWR sky130_fd_sc_hd__decap_4
X_878_ _443_ VGND VGND VPWR VPWR _054_ sky130_fd_sc_hd__inv_2
XFILLER_0_21_62 VGND VGND VPWR VPWR sky130_fd_sc_hd__decap_8
XFILLER_0_24_194 VGND VGND VPWR VPWR sky130_fd_sc_hd__fill_2
XFILLER_0_34_3 VPWR VGND VPWR VGND sky130_ef_sc_hd__decap_12
XFILLER_0_15_161 VGND VGND VPWR VPWR sky130_fd_sc_hd__decap_6
XFILLER_0_30_153 VPWR VGND VPWR VGND sky130_ef_sc_hd__decap_12
X_801_ _398_ _399_ _400_ VGND VGND VPWR VPWR _402_ sky130_fd_sc_hd__o21a_1
X_732_ _147_ VGND VGND VPWR VPWR _344_ sky130_fd_sc_hd__inv_2
XFILLER_0_26_29 VGND VGND VPWR VPWR sky130_fd_sc_hd__decap_3
X_663_ _250_ _251_ _248_ VGND VGND VPWR VPWR _278_ sky130_fd_sc_hd__a21oi_1
X_594_ _178_ net37 net41 VGND VGND VPWR VPWR _211_ sky130_fd_sc_hd__a21oi_2
XFILLER_0_38_297 VGND VGND VPWR VPWR sky130_fd_sc_hd__fill_2
XFILLER_0_38_253 VPWR VGND VPWR VGND sky130_ef_sc_hd__decap_12
XTAP_337 VGND VPWR sky130_fd_sc_hd__tapvpwrvgnd_1
XTAP_326 VGND VPWR sky130_fd_sc_hd__tapvpwrvgnd_1
XTAP_315 VGND VPWR sky130_fd_sc_hd__tapvpwrvgnd_1
XTAP_304 VGND VPWR sky130_fd_sc_hd__tapvpwrvgnd_1
XFILLER_0_32_83 VGND VGND VPWR VPWR sky130_fd_sc_hd__fill_1
XFILLER_0_44_289 VGND VGND VPWR VPWR sky130_fd_sc_hd__fill_1
XFILLER_0_44_245 VGND VGND VPWR VPWR sky130_fd_sc_hd__decap_6
XFILLER_0_12_197 VPWR VGND VPWR VGND sky130_ef_sc_hd__decap_12
XFILLER_0_35_278 VGND VGND VPWR VPWR sky130_fd_sc_hd__fill_2
Xoutput31 net31 VGND VGND VPWR VPWR accumulator[7] sky130_fd_sc_hd__clkbuf_4
Xoutput20 net20 VGND VGND VPWR VPWR accumulator[11] sky130_fd_sc_hd__clkbuf_4
XFILLER_0_37_39 VGND VGND VPWR VPWR sky130_fd_sc_hd__decap_8
X_715_ _300_ _309_ _327_ VGND VGND VPWR VPWR _328_ sky130_fd_sc_hd__nor3_1
X_646_ _085_ _152_ net17 _086_ VGND VGND VPWR VPWR _261_ sky130_fd_sc_hd__a22oi_1
X_577_ _085_ _086_ _064_ _077_ VGND VGND VPWR VPWR _194_ sky130_fd_sc_hd__and4_1
XFILLER_0_41_237 VPWR VGND VPWR VGND sky130_ef_sc_hd__decap_12
XFILLER_0_26_234 VPWR VGND VPWR VGND sky130_ef_sc_hd__decap_12
XTAP_134 VGND VPWR sky130_fd_sc_hd__tapvpwrvgnd_1
XTAP_123 VGND VPWR sky130_fd_sc_hd__tapvpwrvgnd_1
XTAP_112 VGND VPWR sky130_fd_sc_hd__tapvpwrvgnd_1
XTAP_101 VGND VPWR sky130_fd_sc_hd__tapvpwrvgnd_1
XTAP_145 VGND VPWR sky130_fd_sc_hd__tapvpwrvgnd_1
XTAP_156 VGND VPWR sky130_fd_sc_hd__tapvpwrvgnd_1
XTAP_167 VGND VPWR sky130_fd_sc_hd__tapvpwrvgnd_1
XTAP_178 VGND VPWR sky130_fd_sc_hd__tapvpwrvgnd_1
XTAP_189 VGND VPWR sky130_fd_sc_hd__tapvpwrvgnd_1
XFILLER_0_43_93 VPWR VGND VPWR VGND sky130_ef_sc_hd__decap_12
XFILLER_0_17_256 VPWR VGND VPWR VGND sky130_ef_sc_hd__decap_12
XFILLER_0_32_237 VPWR VGND VPWR VGND sky130_ef_sc_hd__decap_12
XFILLER_0_7_93 VPWR VGND VPWR VGND sky130_ef_sc_hd__decap_12
X_500_ _117_ _118_ VGND VGND VPWR VPWR _119_ sky130_fd_sc_hd__nor2_1
XFILLER_0_2_109 VPWR VGND VPWR VGND sky130_ef_sc_hd__decap_12
XFILLER_0_23_204 VPWR VGND VPWR VGND sky130_ef_sc_hd__decap_12
XFILLER_0_23_237 VGND VGND VPWR VPWR sky130_fd_sc_hd__fill_1
Xrebuffer8 _210_ VGND VGND VPWR VPWR net41 sky130_fd_sc_hd__clkbuf_1
XFILLER_0_31_281 VGND VGND VPWR VPWR sky130_fd_sc_hd__decap_4
X_629_ _242_ _243_ _217_ _218_ VGND VGND VPWR VPWR _245_ sky130_fd_sc_hd__a211o_1
XFILLER_0_13_74 VPWR VGND VPWR VGND sky130_ef_sc_hd__decap_12
XFILLER_0_13_281 VPWR VGND VPWR VGND sky130_ef_sc_hd__decap_12
XFILLER_0_34_29 VPWR VGND VPWR VGND sky130_ef_sc_hd__decap_12
XFILLER_0_40_83 VGND VGND VPWR VPWR sky130_fd_sc_hd__fill_1
XFILLER_0_6_289 VGND VGND VPWR VPWR sky130_fd_sc_hd__decap_8
XFILLER_0_6_245 VGND VGND VPWR VPWR sky130_fd_sc_hd__decap_6
XFILLER_0_4_83 VGND VGND VPWR VPWR sky130_fd_sc_hd__fill_1
XFILLER_0_45_181 VPWR VGND VPWR VGND sky130_ef_sc_hd__decap_12
X_894_ clknet_2_2__leaf_clk _012_ _038_ VGND VGND VPWR VPWR net30 sky130_fd_sc_hd__dfrtp_1
XFILLER_0_45_39 VPWR VGND VPWR VGND sky130_ef_sc_hd__decap_12
XFILLER_0_28_148 VGND VGND VPWR VPWR sky130_fd_sc_hd__decap_8
XFILLER_0_3_237 VPWR VGND VPWR VGND sky130_ef_sc_hd__decap_12
XFILLER_0_10_53 VPWR VGND VPWR VGND sky130_ef_sc_hd__decap_12
XFILLER_0_36_7 VPWR VGND VPWR VGND sky130_ef_sc_hd__decap_12
XFILLER_0_35_72 VGND VGND VPWR VPWR sky130_fd_sc_hd__fill_1
XFILLER_0_42_195 VGND VGND VPWR VPWR sky130_fd_sc_hd__fill_1
XFILLER_0_33_140 VGND VGND VPWR VPWR sky130_fd_sc_hd__decap_4
X_877_ _443_ VGND VGND VPWR VPWR _053_ sky130_fd_sc_hd__inv_2
XFILLER_0_16_107 VPWR VGND VPWR VGND sky130_ef_sc_hd__decap_12
XFILLER_0_21_41 VPWR VGND VPWR VGND sky130_ef_sc_hd__decap_12
XFILLER_0_46_93 VPWR VGND VPWR VGND sky130_ef_sc_hd__decap_12
XFILLER_0_1_51 VGND VGND VPWR VPWR sky130_fd_sc_hd__decap_4
XFILLER_0_27_3 VGND VGND VPWR VPWR sky130_fd_sc_hd__decap_4
XFILLER_0_30_165 VGND VGND VPWR VPWR sky130_fd_sc_hd__fill_2
X_800_ _398_ _401_ VGND VGND VPWR VPWR _012_ sky130_fd_sc_hd__xnor2_1
X_731_ _341_ _342_ VGND VGND VPWR VPWR _343_ sky130_fd_sc_hd__and2_1
X_662_ _275_ _276_ VGND VGND VPWR VPWR _277_ sky130_fd_sc_hd__nor2_1
XFILLER_0_42_29 VPWR VGND VPWR VGND sky130_ef_sc_hd__decap_12
XFILLER_0_38_265 VPWR VGND VPWR VGND sky130_ef_sc_hd__decap_12
XFILLER_0_38_221 VPWR VGND VPWR VGND sky130_ef_sc_hd__decap_12
X_593_ _180_ _209_ VGND VGND VPWR VPWR _210_ sky130_fd_sc_hd__xnor2_1
XTAP_338 VGND VPWR sky130_fd_sc_hd__tapvpwrvgnd_1
XTAP_327 VGND VPWR sky130_fd_sc_hd__tapvpwrvgnd_1
XTAP_316 VGND VPWR sky130_fd_sc_hd__tapvpwrvgnd_1
XTAP_305 VGND VPWR sky130_fd_sc_hd__tapvpwrvgnd_1
XFILLER_0_6_29 VPWR VGND VPWR VGND sky130_ef_sc_hd__decap_12
XFILLER_0_8_137 VGND VGND VPWR VPWR sky130_fd_sc_hd__decap_3
XFILLER_0_8_126 VGND VGND VPWR VPWR sky130_fd_sc_hd__decap_3
XFILLER_0_29_221 VGND VGND VPWR VPWR sky130_fd_sc_hd__decap_3
XFILLER_0_7_181 VPWR VGND VPWR VGND sky130_ef_sc_hd__decap_12
Xoutput21 net21 VGND VGND VPWR VPWR accumulator[12] sky130_fd_sc_hd__clkbuf_4
Xoutput32 net32 VGND VGND VPWR VPWR accumulator[8] sky130_fd_sc_hd__clkbuf_4
X_645_ _258_ _259_ VGND VGND VPWR VPWR _260_ sky130_fd_sc_hd__nor2_1
X_714_ _325_ _326_ VGND VGND VPWR VPWR _327_ sky130_fd_sc_hd__nor2_1
X_576_ _191_ _192_ VGND VGND VPWR VPWR _193_ sky130_fd_sc_hd__xnor2_1
XFILLER_0_26_246 VGND VGND VPWR VPWR sky130_fd_sc_hd__decap_6
XFILLER_0_41_249 VPWR VGND VPWR VGND sky130_ef_sc_hd__decap_12
XFILLER_0_41_205 VPWR VGND VPWR VGND sky130_ef_sc_hd__decap_12
XTAP_135 VGND VPWR sky130_fd_sc_hd__tapvpwrvgnd_1
XTAP_124 VGND VPWR sky130_fd_sc_hd__tapvpwrvgnd_1
XTAP_113 VGND VPWR sky130_fd_sc_hd__tapvpwrvgnd_1
XTAP_102 VGND VPWR sky130_fd_sc_hd__tapvpwrvgnd_1
XTAP_146 VGND VPWR sky130_fd_sc_hd__tapvpwrvgnd_1
XTAP_157 VGND VPWR sky130_fd_sc_hd__tapvpwrvgnd_1
XTAP_168 VGND VPWR sky130_fd_sc_hd__tapvpwrvgnd_1
XTAP_179 VGND VPWR sky130_fd_sc_hd__tapvpwrvgnd_1
XFILLER_0_27_95 VGND VGND VPWR VPWR sky130_fd_sc_hd__decap_3
XFILLER_0_32_227 VGND VGND VPWR VPWR sky130_fd_sc_hd__decap_4
XFILLER_0_17_213 VGND VGND VPWR VPWR sky130_fd_sc_hd__fill_1
XFILLER_0_17_268 VPWR VGND VPWR VGND sky130_ef_sc_hd__decap_12
XFILLER_0_32_249 VGND VGND VPWR VPWR sky130_fd_sc_hd__decap_3
XFILLER_0_4_195 VGND VGND VPWR VPWR sky130_fd_sc_hd__fill_1
XFILLER_0_2_9 VPWR VGND VPWR VGND sky130_ef_sc_hd__decap_12
Xrebuffer9 _421_ VGND VGND VPWR VPWR net42 sky130_fd_sc_hd__clkbuf_1
XFILLER_0_23_216 VGND VGND VPWR VPWR sky130_fd_sc_hd__decap_8
X_628_ _217_ _218_ _242_ _243_ VGND VGND VPWR VPWR _244_ sky130_fd_sc_hd__o211ai_4
XFILLER_0_13_86 VPWR VGND VPWR VGND sky130_ef_sc_hd__decap_12
X_559_ _140_ _176_ VGND VGND VPWR VPWR _177_ sky130_fd_sc_hd__and2_1
XFILLER_0_14_249 VGND VGND VPWR VPWR sky130_fd_sc_hd__decap_3
XFILLER_0_9_210 VPWR VGND VPWR VGND sky130_ef_sc_hd__decap_12
XFILLER_0_13_293 VGND VGND VPWR VPWR sky130_fd_sc_hd__decap_6
XFILLER_0_46_105 VGND VGND VPWR VPWR sky130_fd_sc_hd__decap_6
XFILLER_0_24_41 VPWR VGND VPWR VGND sky130_ef_sc_hd__decap_12
XFILLER_0_24_85 VPWR VGND VPWR VGND sky130_ef_sc_hd__decap_12
XFILLER_0_45_193 VPWR VGND VPWR VGND sky130_ef_sc_hd__decap_12
X_893_ clknet_2_3__leaf_clk _011_ _037_ VGND VGND VPWR VPWR net29 sky130_fd_sc_hd__dfrtp_1
XFILLER_0_36_193 VGND VGND VPWR VPWR sky130_fd_sc_hd__decap_3
XFILLER_0_36_171 VGND VGND VPWR VPWR sky130_fd_sc_hd__fill_2
XFILLER_0_3_249 VPWR VGND VPWR VGND sky130_ef_sc_hd__decap_12
XFILLER_0_3_205 VPWR VGND VPWR VGND sky130_ef_sc_hd__decap_12
XFILLER_0_10_65 VPWR VGND VPWR VGND sky130_ef_sc_hd__decap_12
XFILLER_0_19_116 VGND VGND VPWR VPWR sky130_fd_sc_hd__decap_8
XFILLER_0_42_141 VPWR VGND VPWR VGND sky130_ef_sc_hd__decap_12
XFILLER_0_33_152 VPWR VGND VPWR VGND sky130_ef_sc_hd__decap_12
XFILLER_0_18_160 VGND VGND VPWR VPWR sky130_fd_sc_hd__decap_3
X_876_ _443_ VGND VGND VPWR VPWR _052_ sky130_fd_sc_hd__inv_2
XFILLER_0_21_53 VGND VGND VPWR VPWR sky130_fd_sc_hd__decap_3
XFILLER_0_24_174 VGND VGND VPWR VPWR sky130_fd_sc_hd__fill_2
XFILLER_0_46_83 VGND VGND VPWR VPWR sky130_fd_sc_hd__fill_1
X_730_ _333_ _321_ _340_ VGND VGND VPWR VPWR _342_ sky130_fd_sc_hd__o21ai_1
X_661_ _244_ _246_ _274_ VGND VGND VPWR VPWR _276_ sky130_fd_sc_hd__and3_1
X_592_ _207_ _208_ VGND VGND VPWR VPWR _209_ sky130_fd_sc_hd__xor2_1
XFILLER_0_38_277 VPWR VGND VPWR VGND sky130_ef_sc_hd__decap_12
XFILLER_0_38_233 VPWR VGND VPWR VGND sky130_ef_sc_hd__decap_12
XTAP_328 VGND VPWR sky130_fd_sc_hd__tapvpwrvgnd_1
XTAP_317 VGND VPWR sky130_fd_sc_hd__tapvpwrvgnd_1
XTAP_306 VGND VPWR sky130_fd_sc_hd__tapvpwrvgnd_1
X_859_ _441_ VGND VGND VPWR VPWR _037_ sky130_fd_sc_hd__inv_2
XFILLER_0_32_85 VPWR VGND VPWR VGND sky130_ef_sc_hd__decap_12
XFILLER_0_32_41 VGND VGND VPWR VPWR sky130_fd_sc_hd__fill_1
XFILLER_0_35_225 VPWR VGND VPWR VGND sky130_ef_sc_hd__decap_12
XFILLER_0_7_193 VPWR VGND VPWR VGND sky130_ef_sc_hd__decap_12
Xoutput33 net33 VGND VGND VPWR VPWR accumulator[9] sky130_fd_sc_hd__clkbuf_4
Xoutput22 net22 VGND VGND VPWR VPWR accumulator[13] sky130_fd_sc_hd__clkbuf_4
X_644_ _077_ _078_ _116_ net6 VGND VGND VPWR VPWR _259_ sky130_fd_sc_hd__and4_1
X_575_ _087_ _145_ VGND VGND VPWR VPWR _192_ sky130_fd_sc_hd__nand2_1
X_713_ _310_ _324_ VGND VGND VPWR VPWR _326_ sky130_fd_sc_hd__and2_1
XFILLER_0_41_217 VGND VGND VPWR VPWR sky130_fd_sc_hd__decap_6
XTAP_114 VGND VPWR sky130_fd_sc_hd__tapvpwrvgnd_1
XTAP_103 VGND VPWR sky130_fd_sc_hd__tapvpwrvgnd_1
XTAP_136 VGND VPWR sky130_fd_sc_hd__tapvpwrvgnd_1
XTAP_125 VGND VPWR sky130_fd_sc_hd__tapvpwrvgnd_1
XTAP_147 VGND VPWR sky130_fd_sc_hd__tapvpwrvgnd_1
XTAP_158 VGND VPWR sky130_fd_sc_hd__tapvpwrvgnd_1
XTAP_169 VGND VPWR sky130_fd_sc_hd__tapvpwrvgnd_1
XFILLER_0_27_41 VGND VGND VPWR VPWR sky130_fd_sc_hd__decap_6
XFILLER_0_43_51 VGND VGND VPWR VPWR sky130_fd_sc_hd__decap_4
XFILLER_0_4_141 VPWR VGND VPWR VGND sky130_ef_sc_hd__decap_12
XFILLER_0_17_225 VGND VGND VPWR VPWR sky130_fd_sc_hd__decap_6
XFILLER_0_7_51 VGND VGND VPWR VPWR sky130_fd_sc_hd__decap_4
XFILLER_0_31_261 VPWR VGND VPWR VGND sky130_ef_sc_hd__decap_12
X_627_ _240_ _241_ _225_ VGND VGND VPWR VPWR _243_ sky130_fd_sc_hd__a21o_1
X_558_ _135_ _136_ _105_ VGND VGND VPWR VPWR _176_ sky130_fd_sc_hd__or3b_1
XFILLER_0_13_98 VPWR VGND VPWR VGND sky130_ef_sc_hd__decap_12
X_489_ _103_ _108_ VGND VGND VPWR VPWR _109_ sky130_fd_sc_hd__or2b_1
XFILLER_0_1_111 VGND VGND VPWR VPWR sky130_fd_sc_hd__fill_1
XFILLER_0_22_250 VGND VGND VPWR VPWR sky130_fd_sc_hd__fill_2
XFILLER_0_9_222 VGND VGND VPWR VPWR sky130_fd_sc_hd__fill_2
XFILLER_0_46_139 VGND VGND VPWR VPWR sky130_fd_sc_hd__fill_1
XFILLER_0_24_53 VPWR VGND VPWR VGND sky130_ef_sc_hd__decap_12
XFILLER_0_24_97 VPWR VGND VPWR VGND sky130_ef_sc_hd__decap_12
XFILLER_0_40_85 VPWR VGND VPWR VGND sky130_ef_sc_hd__decap_12
XFILLER_0_40_41 VPWR VGND VPWR VGND sky130_ef_sc_hd__decap_12
XFILLER_0_4_85 VPWR VGND VPWR VGND sky130_ef_sc_hd__decap_12
XFILLER_0_4_41 VPWR VGND VPWR VGND sky130_ef_sc_hd__decap_12
XFILLER_0_10_253 VPWR VGND VPWR VGND sky130_ef_sc_hd__decap_12
XFILLER_0_10_297 VGND VGND VPWR VPWR sky130_fd_sc_hd__fill_2
XFILLER_0_45_161 VGND VGND VPWR VPWR sky130_fd_sc_hd__decap_6
X_892_ clknet_2_2__leaf_clk _010_ _036_ VGND VGND VPWR VPWR net28 sky130_fd_sc_hd__dfrtp_1
XFILLER_0_3_217 VGND VGND VPWR VPWR sky130_fd_sc_hd__decap_6
XFILLER_0_10_77 VGND VGND VPWR VPWR sky130_fd_sc_hd__decap_6
XFILLER_0_42_197 VPWR VGND VPWR VGND sky130_ef_sc_hd__decap_12
XFILLER_0_42_153 VPWR VGND VPWR VGND sky130_ef_sc_hd__decap_12
XFILLER_0_33_164 VGND VGND VPWR VPWR sky130_fd_sc_hd__decap_4
XFILLER_0_0_209 VGND VGND VPWR VPWR sky130_fd_sc_hd__decap_3
X_875_ net9 VGND VGND VPWR VPWR _443_ sky130_fd_sc_hd__buf_4
XFILLER_0_24_164 VGND VGND VPWR VPWR sky130_fd_sc_hd__fill_2
XFILLER_0_24_186 VGND VGND VPWR VPWR sky130_fd_sc_hd__decap_8
XFILLER_0_30_134 VGND VGND VPWR VPWR sky130_fd_sc_hd__fill_1
X_591_ _167_ _169_ VGND VGND VPWR VPWR _208_ sky130_fd_sc_hd__nand2_1
X_660_ _244_ _246_ _274_ VGND VGND VPWR VPWR _275_ sky130_fd_sc_hd__a21oi_1
XFILLER_0_38_289 VGND VGND VPWR VPWR sky130_fd_sc_hd__decap_8
XFILLER_0_38_245 VGND VGND VPWR VPWR sky130_fd_sc_hd__decap_6
XTAP_329 VGND VPWR sky130_fd_sc_hd__tapvpwrvgnd_1
XTAP_318 VGND VPWR sky130_fd_sc_hd__tapvpwrvgnd_1
XTAP_307 VGND VPWR sky130_fd_sc_hd__tapvpwrvgnd_1
X_858_ _441_ VGND VGND VPWR VPWR _036_ sky130_fd_sc_hd__inv_2
X_789_ _391_ _392_ VGND VGND VPWR VPWR _393_ sky130_fd_sc_hd__and2b_1
XFILLER_0_32_97 VGND VGND VPWR VPWR sky130_fd_sc_hd__decap_6
XFILLER_0_32_3 VGND VGND VPWR VPWR sky130_fd_sc_hd__decap_8
XFILLER_0_35_237 VPWR VGND VPWR VGND sky130_ef_sc_hd__decap_12
Xoutput23 net23 VGND VGND VPWR VPWR accumulator[14] sky130_fd_sc_hd__clkbuf_4
XFILLER_0_43_281 VPWR VGND VPWR VGND sky130_ef_sc_hd__decap_12
XFILLER_0_7_161 VGND VGND VPWR VPWR sky130_fd_sc_hd__decap_6
X_712_ _310_ _324_ VGND VGND VPWR VPWR _325_ sky130_fd_sc_hd__nor2_1
X_643_ _078_ _116_ net6 _077_ VGND VGND VPWR VPWR _258_ sky130_fd_sc_hd__a22oi_1
X_574_ _189_ _190_ VGND VGND VPWR VPWR _191_ sky130_fd_sc_hd__nor2_1
XFILLER_0_34_292 VGND VGND VPWR VPWR sky130_fd_sc_hd__decap_6
XTAP_137 VGND VPWR sky130_fd_sc_hd__tapvpwrvgnd_1
XTAP_126 VGND VPWR sky130_fd_sc_hd__tapvpwrvgnd_1
XTAP_115 VGND VPWR sky130_fd_sc_hd__tapvpwrvgnd_1
XTAP_104 VGND VPWR sky130_fd_sc_hd__tapvpwrvgnd_1
XTAP_148 VGND VPWR sky130_fd_sc_hd__tapvpwrvgnd_1
XTAP_159 VGND VPWR sky130_fd_sc_hd__tapvpwrvgnd_1
XFILLER_0_27_64 VPWR VGND VPWR VGND sky130_ef_sc_hd__decap_12
XFILLER_0_40_251 VGND VGND VPWR VPWR sky130_fd_sc_hd__fill_1
XFILLER_0_4_197 VPWR VGND VPWR VGND sky130_ef_sc_hd__decap_12
XFILLER_0_4_153 VPWR VGND VPWR VGND sky130_ef_sc_hd__decap_12
XFILLER_0_25_270 VGND VGND VPWR VPWR sky130_fd_sc_hd__decap_3
XFILLER_0_25_281 VPWR VGND VPWR VGND sky130_ef_sc_hd__decap_12
XFILLER_0_31_273 VGND VGND VPWR VPWR sky130_fd_sc_hd__decap_6
XFILLER_0_13_55 VGND VGND VPWR VPWR sky130_fd_sc_hd__fill_1
X_488_ _087_ _065_ _101_ _102_ VGND VGND VPWR VPWR _108_ sky130_fd_sc_hd__a22o_1
X_626_ _225_ _240_ _241_ VGND VGND VPWR VPWR _242_ sky130_fd_sc_hd__nand3_2
X_557_ net38 _174_ VGND VGND VPWR VPWR _175_ sky130_fd_sc_hd__nor2_1
XFILLER_0_14_218 VGND VGND VPWR VPWR sky130_fd_sc_hd__fill_1
XFILLER_0_38_85 VGND VGND VPWR VPWR sky130_fd_sc_hd__fill_2
XFILLER_0_38_41 VPWR VGND VPWR VGND sky130_ef_sc_hd__decap_12
XFILLER_0_1_167 VGND VGND VPWR VPWR sky130_fd_sc_hd__fill_1
X_609_ _223_ _224_ VGND VGND VPWR VPWR _225_ sky130_fd_sc_hd__nor2_1
XFILLER_0_39_181 VPWR VGND VPWR VGND sky130_ef_sc_hd__decap_12
XFILLER_0_40_53 VPWR VGND VPWR VGND sky130_ef_sc_hd__decap_12
XFILLER_0_24_65 VGND VGND VPWR VPWR sky130_fd_sc_hd__fill_2
XFILLER_0_40_97 VPWR VGND VPWR VGND sky130_ef_sc_hd__decap_12
XFILLER_0_4_97 VPWR VGND VPWR VGND sky130_ef_sc_hd__decap_12
XFILLER_0_4_53 VPWR VGND VPWR VGND sky130_ef_sc_hd__decap_12
XFILLER_0_10_265 VPWR VGND VPWR VGND sky130_ef_sc_hd__decap_12
XFILLER_0_5_281 VPWR VGND VPWR VGND sky130_ef_sc_hd__decap_12
X_891_ clknet_2_2__leaf_clk _009_ _035_ VGND VGND VPWR VPWR net27 sky130_fd_sc_hd__dfrtp_1
XFILLER_0_36_151 VPWR VGND VPWR VGND sky130_ef_sc_hd__decap_12
XFILLER_0_42_121 VPWR VGND VPWR VGND sky130_ef_sc_hd__decap_12
XFILLER_0_27_151 VPWR VGND VPWR VGND sky130_ef_sc_hd__decap_12
XFILLER_0_27_173 VGND VGND VPWR VPWR sky130_fd_sc_hd__fill_1
XFILLER_0_42_165 VPWR VGND VPWR VGND sky130_ef_sc_hd__decap_12
XFILLER_0_2_251 VGND VGND VPWR VPWR sky130_fd_sc_hd__fill_1
XFILLER_0_18_173 VGND VGND VPWR VPWR sky130_fd_sc_hd__decap_4
XFILLER_0_18_195 VGND VGND VPWR VPWR sky130_fd_sc_hd__fill_1
X_874_ _442_ VGND VGND VPWR VPWR _051_ sky130_fd_sc_hd__inv_2
XFILLER_0_21_11 VGND VGND VPWR VPWR sky130_fd_sc_hd__fill_1
XFILLER_0_21_33 VGND VGND VPWR VPWR sky130_fd_sc_hd__fill_1
XFILLER_0_24_121 VPWR VGND VPWR VGND sky130_ef_sc_hd__decap_12
XFILLER_0_46_85 VGND VGND VPWR VPWR sky130_fd_sc_hd__fill_2
XFILLER_0_46_63 VPWR VGND VPWR VGND sky130_ef_sc_hd__decap_12
XFILLER_0_46_41 VPWR VGND VPWR VGND sky130_ef_sc_hd__decap_12
XFILLER_0_15_187 VGND VGND VPWR VPWR sky130_fd_sc_hd__decap_3
X_590_ _187_ net40 VGND VGND VPWR VPWR _207_ sky130_fd_sc_hd__xnor2_1
XTAP_319 VGND VPWR sky130_fd_sc_hd__tapvpwrvgnd_1
XTAP_308 VGND VPWR sky130_fd_sc_hd__tapvpwrvgnd_1
XFILLER_0_21_113 VGND VGND VPWR VPWR sky130_fd_sc_hd__decap_8
XFILLER_0_21_124 VGND VGND VPWR VPWR sky130_fd_sc_hd__fill_1
XFILLER_0_21_135 VPWR VGND VPWR VGND sky130_ef_sc_hd__decap_12
XFILLER_0_21_179 VGND VGND VPWR VPWR sky130_fd_sc_hd__decap_6
XFILLER_0_16_44 VGND VGND VPWR VPWR sky130_fd_sc_hd__decap_3
X_788_ mult_reg\[4\] net28 VGND VGND VPWR VPWR _392_ sky130_fd_sc_hd__nand2_1
X_857_ _441_ VGND VGND VPWR VPWR _035_ sky130_fd_sc_hd__inv_2
XFILLER_0_32_65 VPWR VGND VPWR VGND sky130_ef_sc_hd__decap_12
XFILLER_0_16_55 VPWR VGND VPWR VGND sky130_ef_sc_hd__decap_12
XFILLER_0_25_3 VGND VGND VPWR VPWR sky130_fd_sc_hd__decap_8
XFILLER_0_35_249 VGND VGND VPWR VPWR sky130_fd_sc_hd__decap_4
XFILLER_0_43_293 VGND VGND VPWR VPWR sky130_fd_sc_hd__decap_6
Xoutput24 net24 VGND VGND VPWR VPWR accumulator[15] sky130_fd_sc_hd__clkbuf_4
X_642_ _256_ VGND VGND VPWR VPWR _257_ sky130_fd_sc_hd__inv_2
X_711_ _322_ _323_ VGND VGND VPWR VPWR _324_ sky130_fd_sc_hd__xnor2_1
X_573_ _064_ net1 net5 net17 VGND VGND VPWR VPWR _190_ sky130_fd_sc_hd__and4_1
XFILLER_0_26_205 VGND VGND VPWR VPWR sky130_fd_sc_hd__fill_2
XTAP_138 VGND VPWR sky130_fd_sc_hd__tapvpwrvgnd_1
XTAP_127 VGND VPWR sky130_fd_sc_hd__tapvpwrvgnd_1
XTAP_116 VGND VPWR sky130_fd_sc_hd__tapvpwrvgnd_1
XTAP_105 VGND VPWR sky130_fd_sc_hd__tapvpwrvgnd_1
XTAP_149 VGND VPWR sky130_fd_sc_hd__tapvpwrvgnd_1
XFILLER_0_27_10 VPWR VGND VPWR VGND sky130_ef_sc_hd__decap_12
X_909_ clknet_2_3__leaf_clk _027_ _053_ VGND VGND VPWR VPWR mult_reg\[5\] sky130_fd_sc_hd__dfrtp_1
XFILLER_0_27_76 VPWR VGND VPWR VGND sky130_ef_sc_hd__decap_12
XFILLER_0_4_165 VPWR VGND VPWR VGND sky130_ef_sc_hd__decap_12
XFILLER_0_4_121 VPWR VGND VPWR VGND sky130_ef_sc_hd__decap_12
XFILLER_0_25_293 VGND VGND VPWR VPWR sky130_fd_sc_hd__decap_6
XFILLER_0_31_285 VGND VGND VPWR VPWR sky130_fd_sc_hd__fill_1
X_625_ _238_ _239_ VGND VGND VPWR VPWR _241_ sky130_fd_sc_hd__nand2_1
X_487_ _099_ _100_ VGND VGND VPWR VPWR _107_ sky130_fd_sc_hd__and2_1
X_556_ _097_ _143_ _171_ _172_ VGND VGND VPWR VPWR _174_ sky130_fd_sc_hd__o22a_1
XFILLER_0_1_113 VPWR VGND VPWR VGND sky130_ef_sc_hd__decap_12
XFILLER_0_22_296 VGND VGND VPWR VPWR sky130_fd_sc_hd__decap_3
XFILLER_0_9_279 VGND VGND VPWR VPWR sky130_fd_sc_hd__fill_1
XFILLER_0_0_9 VGND VGND VPWR VPWR sky130_fd_sc_hd__fill_2
XFILLER_0_13_230 VPWR VGND VPWR VGND sky130_ef_sc_hd__decap_12
X_608_ _221_ _222_ VGND VGND VPWR VPWR _224_ sky130_fd_sc_hd__and2_1
XFILLER_0_39_193 VPWR VGND VPWR VGND sky130_ef_sc_hd__decap_12
XFILLER_0_40_65 VPWR VGND VPWR VGND sky130_ef_sc_hd__decap_12
X_539_ net4 net13 net14 net3 VGND VGND VPWR VPWR _157_ sky130_fd_sc_hd__a22o_1
XFILLER_0_24_77 VGND VGND VPWR VPWR sky130_fd_sc_hd__decap_4
XFILLER_0_10_222 VPWR VGND VPWR VGND sky130_ef_sc_hd__decap_12
XFILLER_0_10_277 VPWR VGND VPWR VGND sky130_ef_sc_hd__decap_12
XFILLER_0_4_65 VPWR VGND VPWR VGND sky130_ef_sc_hd__decap_12
XFILLER_0_37_119 VGND VGND VPWR VPWR sky130_fd_sc_hd__fill_1
XFILLER_0_5_293 VGND VGND VPWR VPWR sky130_fd_sc_hd__decap_6
X_890_ clknet_2_2__leaf_clk _008_ _034_ VGND VGND VPWR VPWR net26 sky130_fd_sc_hd__dfrtp_1
XFILLER_0_36_185 VGND VGND VPWR VPWR sky130_fd_sc_hd__decap_8
XFILLER_0_36_163 VGND VGND VPWR VPWR sky130_fd_sc_hd__decap_8
XFILLER_0_36_141 VGND VGND VPWR VPWR sky130_fd_sc_hd__decap_6
XFILLER_0_36_130 VGND VGND VPWR VPWR sky130_fd_sc_hd__decap_8
XFILLER_0_19_55 VGND VGND VPWR VPWR sky130_fd_sc_hd__fill_1
XFILLER_0_19_99 VPWR VGND VPWR VGND sky130_ef_sc_hd__decap_12
XFILLER_0_42_177 VPWR VGND VPWR VGND sky130_ef_sc_hd__decap_12
XFILLER_0_42_133 VGND VGND VPWR VPWR sky130_fd_sc_hd__decap_6
XFILLER_0_27_163 VGND VGND VPWR VPWR sky130_fd_sc_hd__decap_4
XFILLER_0_33_144 VGND VGND VPWR VPWR sky130_fd_sc_hd__fill_1
X_873_ _442_ VGND VGND VPWR VPWR _050_ sky130_fd_sc_hd__inv_2
XFILLER_0_24_133 VGND VGND VPWR VPWR sky130_fd_sc_hd__decap_6
XFILLER_0_24_144 VPWR VGND VPWR VGND sky130_ef_sc_hd__decap_12
XFILLER_0_46_75 VGND VGND VPWR VPWR sky130_fd_sc_hd__decap_8
XFILLER_0_46_53 VGND VGND VPWR VPWR sky130_fd_sc_hd__decap_3
XFILLER_0_1_55 VGND VGND VPWR VPWR sky130_fd_sc_hd__fill_1
Xhold13 reset VGND VGND VPWR VPWR net46 sky130_fd_sc_hd__dlygate4sd3_1
XTAP_309 VGND VPWR sky130_fd_sc_hd__tapvpwrvgnd_1
XFILLER_0_21_147 VPWR VGND VPWR VGND sky130_ef_sc_hd__decap_12
X_856_ _441_ VGND VGND VPWR VPWR _034_ sky130_fd_sc_hd__inv_2
XFILLER_0_16_67 VPWR VGND VPWR VGND sky130_ef_sc_hd__decap_12
X_787_ mult_reg\[4\] net28 VGND VGND VPWR VPWR _391_ sky130_fd_sc_hd__nor2_1
XFILLER_0_32_77 VGND VGND VPWR VPWR sky130_fd_sc_hd__decap_6
XFILLER_0_32_11 VGND VGND VPWR VPWR sky130_fd_sc_hd__fill_2
XFILLER_0_18_3 VPWR VGND VPWR VGND sky130_ef_sc_hd__decap_12
XFILLER_0_43_261 VPWR VGND VPWR VGND sky130_ef_sc_hd__decap_12
Xoutput25 net25 VGND VGND VPWR VPWR accumulator[1] sky130_fd_sc_hd__clkbuf_4
X_710_ _286_ _287_ _298_ _297_ _295_ VGND VGND VPWR VPWR _323_ sky130_fd_sc_hd__o32a_1
X_572_ _064_ _078_ _188_ _065_ VGND VGND VPWR VPWR _189_ sky130_fd_sc_hd__a22oi_1
X_641_ _253_ _255_ VGND VGND VPWR VPWR _256_ sky130_fd_sc_hd__xor2_1
XTAP_139 VGND VPWR sky130_fd_sc_hd__tapvpwrvgnd_1
XTAP_128 VGND VPWR sky130_fd_sc_hd__tapvpwrvgnd_1
XTAP_117 VGND VPWR sky130_fd_sc_hd__tapvpwrvgnd_1
XTAP_106 VGND VPWR sky130_fd_sc_hd__tapvpwrvgnd_1
XFILLER_0_27_22 VGND VGND VPWR VPWR sky130_fd_sc_hd__decap_6
X_908_ clknet_2_2__leaf_clk _020_ _052_ VGND VGND VPWR VPWR mult_reg\[4\] sky130_fd_sc_hd__dfrtp_1
X_839_ _426_ _427_ _428_ VGND VGND VPWR VPWR _433_ sky130_fd_sc_hd__o21a_1
XPHY_0 VGND VGND VPWR VPWR sky130_fd_sc_hd__decap_3
XFILLER_0_32_209 VPWR VGND VPWR VGND sky130_ef_sc_hd__decap_12
XFILLER_0_4_133 VGND VGND VPWR VPWR sky130_fd_sc_hd__decap_6
XFILLER_0_40_297 VGND VGND VPWR VPWR sky130_fd_sc_hd__fill_2
XFILLER_0_40_253 VPWR VGND VPWR VGND sky130_ef_sc_hd__decap_12
XFILLER_0_4_177 VPWR VGND VPWR VGND sky130_ef_sc_hd__decap_12
XFILLER_0_16_250 VGND VGND VPWR VPWR sky130_fd_sc_hd__fill_2
XFILLER_0_31_297 VGND VGND VPWR VPWR sky130_fd_sc_hd__fill_2
XFILLER_0_7_3 VPWR VGND VPWR VGND sky130_ef_sc_hd__decap_12
X_624_ _238_ _239_ VGND VGND VPWR VPWR _240_ sky130_fd_sc_hd__or2_1
X_555_ _097_ _143_ _171_ _172_ VGND VGND VPWR VPWR _173_ sky130_fd_sc_hd__nor4_4
XFILLER_0_13_57 VGND VGND VPWR VPWR sky130_fd_sc_hd__decap_3
X_486_ _097_ _098_ _104_ VGND VGND VPWR VPWR _106_ sky130_fd_sc_hd__a21oi_1
XFILLER_0_1_125 VPWR VGND VPWR VGND sky130_ef_sc_hd__decap_12
XFILLER_0_1_169 VPWR VGND VPWR VGND sky130_ef_sc_hd__decap_12
XFILLER_0_22_253 VGND VGND VPWR VPWR sky130_fd_sc_hd__decap_8
XFILLER_0_22_264 VPWR VGND VPWR VGND sky130_ef_sc_hd__decap_12
XFILLER_0_38_76 VGND VGND VPWR VPWR sky130_fd_sc_hd__fill_2
XFILLER_0_9_225 VPWR VGND VPWR VGND sky130_ef_sc_hd__decap_12
XFILLER_0_13_242 VPWR VGND VPWR VGND sky130_ef_sc_hd__decap_12
X_538_ _151_ _155_ VGND VGND VPWR VPWR _156_ sky130_fd_sc_hd__xnor2_1
X_607_ _221_ _222_ VGND VGND VPWR VPWR _223_ sky130_fd_sc_hd__nor2_1
XFILLER_0_40_77 VGND VGND VPWR VPWR sky130_fd_sc_hd__decap_6
X_469_ net11 _085_ _086_ net12 VGND VGND VPWR VPWR _089_ sky130_fd_sc_hd__a22o_1
XFILLER_0_10_234 VPWR VGND VPWR VGND sky130_ef_sc_hd__decap_12
XFILLER_0_10_289 VGND VGND VPWR VPWR sky130_fd_sc_hd__decap_8
XFILLER_0_4_77 VGND VGND VPWR VPWR sky130_fd_sc_hd__decap_6
XFILLER_0_37_109 VGND VGND VPWR VPWR sky130_fd_sc_hd__decap_3
XFILLER_0_5_261 VPWR VGND VPWR VGND sky130_ef_sc_hd__decap_12
XFILLER_0_35_55 VGND VGND VPWR VPWR sky130_fd_sc_hd__fill_1
XFILLER_0_19_67 VPWR VGND VPWR VGND sky130_ef_sc_hd__decap_12
XFILLER_0_42_189 VGND VGND VPWR VPWR sky130_fd_sc_hd__decap_6
XFILLER_0_2_253 VPWR VGND VPWR VGND sky130_ef_sc_hd__decap_12
XFILLER_0_2_297 VGND VGND VPWR VPWR sky130_fd_sc_hd__fill_2
XFILLER_0_18_197 VPWR VGND VPWR VGND sky130_ef_sc_hd__decap_12
X_872_ _442_ VGND VGND VPWR VPWR _049_ sky130_fd_sc_hd__inv_2
XFILLER_0_24_156 VGND VGND VPWR VPWR sky130_fd_sc_hd__decap_8
XFILLER_0_15_167 VGND VGND VPWR VPWR sky130_fd_sc_hd__fill_1
XFILLER_0_21_104 VGND VGND VPWR VPWR sky130_fd_sc_hd__decap_8
XFILLER_0_21_159 VGND VGND VPWR VPWR sky130_fd_sc_hd__fill_1
X_786_ _386_ _387_ _388_ VGND VGND VPWR VPWR _390_ sky130_fd_sc_hd__o21a_1
X_855_ _441_ VGND VGND VPWR VPWR _033_ sky130_fd_sc_hd__inv_2
XFILLER_0_37_281 VPWR VGND VPWR VGND sky130_ef_sc_hd__decap_12
XFILLER_0_8_109 VPWR VGND VPWR VGND sky130_ef_sc_hd__decap_12
XFILLER_0_12_104 VPWR VGND VPWR VGND sky130_ef_sc_hd__decap_12
XFILLER_0_12_126 VPWR VGND VPWR VGND sky130_ef_sc_hd__decap_12
XFILLER_0_43_273 VGND VGND VPWR VPWR sky130_fd_sc_hd__decap_6
XFILLER_0_11_192 VPWR VGND VPWR VGND sky130_ef_sc_hd__decap_12
Xoutput26 net26 VGND VGND VPWR VPWR accumulator[2] sky130_fd_sc_hd__buf_2
X_571_ net17 VGND VGND VPWR VPWR _188_ sky130_fd_sc_hd__buf_2
X_640_ _254_ net7 _227_ VGND VGND VPWR VPWR _255_ sky130_fd_sc_hd__mux2_1
XFILLER_0_19_281 VPWR VGND VPWR VGND sky130_ef_sc_hd__decap_12
X_838_ _430_ _431_ VGND VGND VPWR VPWR _432_ sky130_fd_sc_hd__nor2_1
XTAP_129 VGND VPWR sky130_fd_sc_hd__tapvpwrvgnd_1
XTAP_118 VGND VPWR sky130_fd_sc_hd__tapvpwrvgnd_1
XTAP_107 VGND VPWR sky130_fd_sc_hd__tapvpwrvgnd_1
X_907_ clknet_2_2__leaf_clk _019_ _051_ VGND VGND VPWR VPWR mult_reg\[3\] sky130_fd_sc_hd__dfrtp_1
XFILLER_0_43_55 VGND VGND VPWR VPWR sky130_fd_sc_hd__fill_1
XPHY_1 VGND VGND VPWR VPWR sky130_fd_sc_hd__decap_3
X_769_ _377_ VGND VGND VPWR VPWR _026_ sky130_fd_sc_hd__clkbuf_1
XFILLER_0_17_218 VGND VGND VPWR VPWR sky130_fd_sc_hd__decap_6
XFILLER_0_25_262 VGND VGND VPWR VPWR sky130_fd_sc_hd__decap_8
XFILLER_0_40_265 VPWR VGND VPWR VGND sky130_ef_sc_hd__decap_12
XFILLER_0_40_221 VPWR VGND VPWR VGND sky130_ef_sc_hd__decap_12
XFILLER_0_7_55 VGND VGND VPWR VPWR sky130_fd_sc_hd__fill_1
XFILLER_0_4_189 VGND VGND VPWR VPWR sky130_fd_sc_hd__decap_6
X_623_ _193_ _202_ _201_ VGND VGND VPWR VPWR _239_ sky130_fd_sc_hd__a21oi_1
X_485_ _097_ _098_ _104_ VGND VGND VPWR VPWR _105_ sky130_fd_sc_hd__and3_1
X_554_ _169_ _170_ _144_ _135_ VGND VGND VPWR VPWR _172_ sky130_fd_sc_hd__a211oi_2
XFILLER_0_1_137 VPWR VGND VPWR VGND sky130_ef_sc_hd__decap_12
XFILLER_0_22_276 VPWR VGND VPWR VGND sky130_ef_sc_hd__decap_12
XFILLER_0_9_237 VPWR VGND VPWR VGND sky130_ef_sc_hd__decap_12
XFILLER_0_13_254 VPWR VGND VPWR VGND sky130_ef_sc_hd__decap_12
XFILLER_0_39_151 VPWR VGND VPWR VGND sky130_ef_sc_hd__decap_12
X_468_ _084_ _085_ _086_ _087_ VGND VGND VPWR VPWR _088_ sky130_fd_sc_hd__nand4_2
X_537_ _153_ _154_ VGND VGND VPWR VPWR _155_ sky130_fd_sc_hd__nor2_1
X_606_ _084_ _181_ VGND VGND VPWR VPWR _222_ sky130_fd_sc_hd__and2_1
XFILLER_0_10_246 VGND VGND VPWR VPWR sky130_fd_sc_hd__decap_6
XFILLER_0_5_273 VGND VGND VPWR VPWR sky130_fd_sc_hd__decap_6
XTAP_290 VGND VPWR sky130_fd_sc_hd__tapvpwrvgnd_1
XFILLER_0_10_15 VPWR VGND VPWR VGND sky130_ef_sc_hd__decap_12
XFILLER_0_19_79 VPWR VGND VPWR VGND sky130_ef_sc_hd__decap_12
XFILLER_0_27_110 VGND VGND VPWR VPWR sky130_fd_sc_hd__fill_2
XFILLER_0_2_265 VPWR VGND VPWR VGND sky130_ef_sc_hd__decap_12
XFILLER_0_2_221 VPWR VGND VPWR VGND sky130_ef_sc_hd__decap_12
XFILLER_0_18_110 VPWR VGND VPWR VGND sky130_ef_sc_hd__decap_12
X_871_ _442_ VGND VGND VPWR VPWR _048_ sky130_fd_sc_hd__inv_2
XFILLER_0_1_57 VPWR VGND VPWR VGND sky130_ef_sc_hd__decap_12
XFILLER_0_15_113 VGND VGND VPWR VPWR sky130_fd_sc_hd__decap_8
XFILLER_0_15_179 VGND VGND VPWR VPWR sky130_fd_sc_hd__decap_8
XFILLER_0_30_138 VGND VGND VPWR VPWR sky130_fd_sc_hd__fill_2
X_854_ _441_ VGND VGND VPWR VPWR _032_ sky130_fd_sc_hd__inv_2
X_785_ _386_ _389_ VGND VGND VPWR VPWR _009_ sky130_fd_sc_hd__xnor2_1
XFILLER_0_37_293 VGND VGND VPWR VPWR sky130_fd_sc_hd__fill_2
XFILLER_0_12_138 VGND VGND VPWR VPWR sky130_fd_sc_hd__fill_2
XFILLER_0_28_282 VGND VGND VPWR VPWR sky130_fd_sc_hd__fill_2
Xoutput27 net27 VGND VGND VPWR VPWR accumulator[3] sky130_fd_sc_hd__clkbuf_4
X_570_ _185_ _186_ VGND VGND VPWR VPWR _187_ sky130_fd_sc_hd__nor2_1
XFILLER_0_19_293 VGND VGND VPWR VPWR sky130_fd_sc_hd__decap_6
XTAP_119 VGND VPWR sky130_fd_sc_hd__tapvpwrvgnd_1
XTAP_108 VGND VPWR sky130_fd_sc_hd__tapvpwrvgnd_1
X_837_ mult_reg\[14\] net23 VGND VGND VPWR VPWR _431_ sky130_fd_sc_hd__nor2_1
X_906_ clknet_2_2__leaf_clk _018_ _050_ VGND VGND VPWR VPWR mult_reg\[2\] sky130_fd_sc_hd__dfrtp_1
X_768_ _375_ _376_ VGND VGND VPWR VPWR _377_ sky130_fd_sc_hd__or2_1
XFILLER_0_27_57 VGND VGND VPWR VPWR sky130_fd_sc_hd__fill_2
XPHY_2 VGND VGND VPWR VPWR sky130_fd_sc_hd__decap_3
X_699_ _078_ _145_ _152_ _188_ VGND VGND VPWR VPWR _312_ sky130_fd_sc_hd__nand4_2
Xclkbuf_0_clk clk VGND VGND VPWR VPWR clknet_0_clk sky130_fd_sc_hd__clkbuf_16
XFILLER_0_40_233 VPWR VGND VPWR VGND sky130_ef_sc_hd__decap_12
XFILLER_0_40_277 VPWR VGND VPWR VGND sky130_ef_sc_hd__decap_12
XFILLER_0_23_3 VPWR VGND VPWR VGND sky130_ef_sc_hd__decap_12
X_622_ _228_ _237_ VGND VGND VPWR VPWR _238_ sky130_fd_sc_hd__xor2_1
XFILLER_0_13_15 VPWR VGND VPWR VGND sky130_ef_sc_hd__decap_12
XFILLER_0_13_37 VPWR VGND VPWR VGND sky130_ef_sc_hd__decap_12
X_484_ _099_ _100_ _103_ VGND VGND VPWR VPWR _104_ sky130_fd_sc_hd__and3_1
X_553_ _144_ _135_ _169_ _170_ VGND VGND VPWR VPWR _171_ sky130_fd_sc_hd__o211a_4
XFILLER_0_1_105 VGND VGND VPWR VPWR sky130_fd_sc_hd__decap_6
XFILLER_0_22_233 VGND VGND VPWR VPWR sky130_fd_sc_hd__fill_2
XFILLER_0_1_149 VPWR VGND VPWR VGND sky130_ef_sc_hd__decap_12
XFILLER_0_22_288 VGND VGND VPWR VPWR sky130_fd_sc_hd__decap_8
XFILLER_0_9_249 VPWR VGND VPWR VGND sky130_ef_sc_hd__decap_12
XFILLER_0_13_211 VPWR VGND VPWR VGND sky130_ef_sc_hd__decap_12
XFILLER_0_13_266 VPWR VGND VPWR VGND sky130_ef_sc_hd__decap_12
X_605_ _219_ _220_ VGND VGND VPWR VPWR _221_ sky130_fd_sc_hd__xnor2_1
XFILLER_0_39_163 VGND VGND VPWR VPWR sky130_fd_sc_hd__decap_4
X_467_ net12 VGND VGND VPWR VPWR _087_ sky130_fd_sc_hd__buf_6
X_536_ net12 net1 net5 net16 VGND VGND VPWR VPWR _154_ sky130_fd_sc_hd__and4_1
XFILLER_0_10_203 VGND VGND VPWR VPWR sky130_fd_sc_hd__fill_1
XFILLER_0_45_111 VGND VGND VPWR VPWR sky130_fd_sc_hd__fill_1
XTAP_291 VGND VPWR sky130_fd_sc_hd__tapvpwrvgnd_1
XTAP_280 VGND VPWR sky130_fd_sc_hd__tapvpwrvgnd_1
XFILLER_0_10_27 VGND VGND VPWR VPWR sky130_fd_sc_hd__fill_1
XFILLER_0_19_47 VGND VGND VPWR VPWR sky130_fd_sc_hd__decap_4
XFILLER_0_35_35 VGND VGND VPWR VPWR sky130_fd_sc_hd__fill_2
XFILLER_0_27_122 VPWR VGND VPWR VGND sky130_ef_sc_hd__decap_12
XFILLER_0_27_144 VGND VGND VPWR VPWR sky130_fd_sc_hd__fill_2
XFILLER_0_27_177 VGND VGND VPWR VPWR sky130_fd_sc_hd__decap_8
X_519_ _135_ _136_ _137_ VGND VGND VPWR VPWR _138_ sky130_fd_sc_hd__or3_4
XFILLER_0_2_277 VPWR VGND VPWR VGND sky130_ef_sc_hd__decap_12
XFILLER_0_2_233 VPWR VGND VPWR VGND sky130_ef_sc_hd__decap_12
XFILLER_0_18_122 VGND VGND VPWR VPWR sky130_fd_sc_hd__decap_4
XFILLER_0_18_133 VGND VGND VPWR VPWR sky130_fd_sc_hd__fill_1
XFILLER_0_33_169 VPWR VGND VPWR VGND sky130_ef_sc_hd__decap_12
XFILLER_0_18_177 VGND VGND VPWR VPWR sky130_fd_sc_hd__fill_1
X_870_ _442_ VGND VGND VPWR VPWR _047_ sky130_fd_sc_hd__inv_2
XFILLER_0_21_15 VPWR VGND VPWR VGND sky130_ef_sc_hd__decap_12
XFILLER_0_46_23 VGND VGND VPWR VPWR sky130_fd_sc_hd__decap_4
XFILLER_0_1_69 VPWR VGND VPWR VGND sky130_ef_sc_hd__decap_12
XFILLER_0_15_169 VGND VGND VPWR VPWR sky130_fd_sc_hd__decap_6
XFILLER_0_30_106 VPWR VGND VPWR VGND sky130_ef_sc_hd__decap_12
XFILLER_0_23_180 VPWR VGND VPWR VGND sky130_ef_sc_hd__decap_12
X_784_ _387_ _388_ VGND VGND VPWR VPWR _389_ sky130_fd_sc_hd__and2b_1
X_853_ net9 VGND VGND VPWR VPWR _441_ sky130_fd_sc_hd__clkbuf_8
XFILLER_0_44_209 VPWR VGND VPWR VGND sky130_ef_sc_hd__decap_12
XFILLER_0_37_261 VPWR VGND VPWR VGND sky130_ef_sc_hd__decap_12
XFILLER_0_7_111 VGND VGND VPWR VPWR sky130_fd_sc_hd__fill_1
Xoutput28 net28 VGND VGND VPWR VPWR accumulator[4] sky130_fd_sc_hd__clkbuf_4
XFILLER_0_9_9 VPWR VGND VPWR VGND sky130_ef_sc_hd__decap_12
XFILLER_0_34_253 VGND VGND VPWR VPWR sky130_fd_sc_hd__fill_1
XTAP_109 VGND VPWR sky130_fd_sc_hd__tapvpwrvgnd_1
X_905_ clknet_2_0__leaf_clk _017_ _049_ VGND VGND VPWR VPWR mult_reg\[1\] sky130_fd_sc_hd__dfrtp_1
X_836_ mult_reg\[14\] net23 VGND VGND VPWR VPWR _430_ sky130_fd_sc_hd__and2_1
X_767_ _357_ _370_ _188_ _181_ VGND VGND VPWR VPWR _376_ sky130_fd_sc_hd__o211a_1
XFILLER_0_27_47 VGND VGND VPWR VPWR sky130_fd_sc_hd__fill_1
XFILLER_0_43_57 VPWR VGND VPWR VGND sky130_ef_sc_hd__decap_12
XPHY_3 VGND VGND VPWR VPWR sky130_fd_sc_hd__decap_3
X_698_ _145_ _152_ _188_ _078_ VGND VGND VPWR VPWR _311_ sky130_fd_sc_hd__a22o_1
XFILLER_0_17_209 VGND VGND VPWR VPWR sky130_fd_sc_hd__decap_4
XFILLER_0_40_245 VGND VGND VPWR VPWR sky130_fd_sc_hd__decap_6
XFILLER_0_7_57 VPWR VGND VPWR VGND sky130_ef_sc_hd__decap_12
XFILLER_0_40_289 VGND VGND VPWR VPWR sky130_fd_sc_hd__decap_8
XFILLER_0_33_90 VGND VGND VPWR VPWR sky130_fd_sc_hd__fill_2
XFILLER_0_16_253 VPWR VGND VPWR VGND sky130_ef_sc_hd__decap_12
XFILLER_0_31_289 VGND VGND VPWR VPWR sky130_fd_sc_hd__decap_8
XFILLER_0_16_297 VGND VGND VPWR VPWR sky130_fd_sc_hd__fill_2
XFILLER_0_31_223 VGND VGND VPWR VPWR sky130_fd_sc_hd__fill_1
X_621_ _235_ _236_ VGND VGND VPWR VPWR _237_ sky130_fd_sc_hd__nand2_1
XFILLER_0_13_27 VGND VGND VPWR VPWR sky130_fd_sc_hd__decap_4
XFILLER_0_13_49 VGND VGND VPWR VPWR sky130_fd_sc_hd__decap_6
X_483_ _087_ _065_ _101_ _102_ VGND VGND VPWR VPWR _103_ sky130_fd_sc_hd__and4_1
X_552_ _167_ _168_ _150_ VGND VGND VPWR VPWR _170_ sky130_fd_sc_hd__a21o_1
X_819_ _415_ _416_ VGND VGND VPWR VPWR _417_ sky130_fd_sc_hd__nand2_1
XFILLER_0_0_161 VGND VGND VPWR VPWR sky130_fd_sc_hd__decap_6
XFILLER_0_13_223 VGND VGND VPWR VPWR sky130_fd_sc_hd__fill_1
XFILLER_0_13_278 VGND VGND VPWR VPWR sky130_fd_sc_hd__fill_2
XFILLER_0_5_3 VPWR VGND VPWR VGND sky130_ef_sc_hd__decap_12
X_535_ _087_ net5 _152_ _065_ VGND VGND VPWR VPWR _153_ sky130_fd_sc_hd__a22oi_1
X_604_ _087_ net7 VGND VGND VPWR VPWR _220_ sky130_fd_sc_hd__nand2_1
XFILLER_0_24_26 VGND VGND VPWR VPWR sky130_fd_sc_hd__fill_2
Xclkbuf_2_0__f_clk clknet_0_clk VGND VGND VPWR VPWR clknet_2_0__leaf_clk sky130_fd_sc_hd__clkbuf_16
XFILLER_0_39_131 VPWR VGND VPWR VGND sky130_ef_sc_hd__decap_12
XFILLER_0_6_209 VPWR VGND VPWR VGND sky130_ef_sc_hd__decap_12
X_466_ net3 VGND VGND VPWR VPWR _086_ sky130_fd_sc_hd__buf_6
XFILLER_0_45_167 VGND VGND VPWR VPWR sky130_fd_sc_hd__fill_1
XFILLER_0_14_92 VPWR VGND VPWR VGND sky130_ef_sc_hd__decap_12
XTAP_292 VGND VPWR sky130_fd_sc_hd__tapvpwrvgnd_1
XTAP_281 VGND VPWR sky130_fd_sc_hd__tapvpwrvgnd_1
XTAP_270 VGND VPWR sky130_fd_sc_hd__tapvpwrvgnd_1
XFILLER_0_19_15 VGND VGND VPWR VPWR sky130_fd_sc_hd__decap_3
X_518_ _098_ _104_ _097_ VGND VGND VPWR VPWR _137_ sky130_fd_sc_hd__a21bo_1
X_449_ net11 net3 net10 net4 VGND VGND VPWR VPWR _069_ sky130_fd_sc_hd__a22o_1
XFILLER_0_27_167 VGND VGND VPWR VPWR sky130_fd_sc_hd__fill_1
XFILLER_0_2_289 VGND VGND VPWR VPWR sky130_fd_sc_hd__decap_8
XFILLER_0_2_245 VGND VGND VPWR VPWR sky130_fd_sc_hd__decap_6
XFILLER_0_41_181 VPWR VGND VPWR VGND sky130_ef_sc_hd__decap_12
XFILLER_0_21_27 VGND VGND VPWR VPWR sky130_fd_sc_hd__decap_6
XFILLER_0_1_15 VPWR VGND VPWR VGND sky130_ef_sc_hd__decap_12
XFILLER_0_11_60 VPWR VGND VPWR VGND sky130_ef_sc_hd__decap_12
XFILLER_0_15_104 VGND VGND VPWR VPWR sky130_fd_sc_hd__decap_8
XFILLER_0_15_137 VPWR VGND VPWR VGND sky130_ef_sc_hd__decap_12
XFILLER_0_23_192 VPWR VGND VPWR VGND sky130_ef_sc_hd__decap_12
XFILLER_0_30_118 VPWR VGND VPWR VGND sky130_ef_sc_hd__decap_12
XFILLER_0_46_251 VGND VGND VPWR VPWR sky130_fd_sc_hd__fill_1
X_852_ _440_ VGND VGND VPWR VPWR _019_ sky130_fd_sc_hd__clkbuf_1
X_783_ mult_reg\[3\] net27 VGND VGND VPWR VPWR _388_ sky130_fd_sc_hd__nand2_1
XFILLER_0_29_229 VGND VGND VPWR VPWR sky130_fd_sc_hd__fill_1
XFILLER_0_37_273 VGND VGND VPWR VPWR sky130_fd_sc_hd__decap_6
XFILLER_0_20_195 VGND VGND VPWR VPWR sky130_fd_sc_hd__fill_1
XFILLER_0_7_167 VGND VGND VPWR VPWR sky130_fd_sc_hd__fill_1
Xoutput29 net29 VGND VGND VPWR VPWR accumulator[5] sky130_fd_sc_hd__buf_2
Xoutput18 net18 VGND VGND VPWR VPWR accumulator[0] sky130_fd_sc_hd__clkbuf_4
XFILLER_0_11_151 VGND VGND VPWR VPWR sky130_fd_sc_hd__decap_4
XFILLER_0_34_298 VGND VGND VPWR VPWR sky130_fd_sc_hd__fill_1
X_904_ clknet_2_0__leaf_clk _016_ _048_ VGND VGND VPWR VPWR mult_reg\[0\] sky130_fd_sc_hd__dfrtp_1
X_835_ _426_ _429_ VGND VGND VPWR VPWR _004_ sky130_fd_sc_hd__xnor2_1
X_697_ _147_ _259_ _287_ VGND VGND VPWR VPWR _310_ sky130_fd_sc_hd__a21oi_1
X_766_ _353_ _373_ _372_ _365_ VGND VGND VPWR VPWR _375_ sky130_fd_sc_hd__o211a_1
XFILLER_0_43_69 VPWR VGND VPWR VGND sky130_ef_sc_hd__decap_12
XPHY_4 VGND VGND VPWR VPWR sky130_fd_sc_hd__decap_3
XFILLER_0_7_69 VPWR VGND VPWR VGND sky130_ef_sc_hd__decap_12
XFILLER_0_25_276 VGND VGND VPWR VPWR sky130_fd_sc_hd__decap_4
XFILLER_0_16_232 VGND VGND VPWR VPWR sky130_fd_sc_hd__fill_2
XFILLER_0_16_265 VPWR VGND VPWR VGND sky130_ef_sc_hd__decap_12
XFILLER_0_31_279 VGND VGND VPWR VPWR sky130_fd_sc_hd__fill_1
XFILLER_0_3_181 VPWR VGND VPWR VGND sky130_ef_sc_hd__decap_12
X_620_ _232_ _233_ _234_ VGND VGND VPWR VPWR _236_ sky130_fd_sc_hd__a21o_1
X_551_ _150_ _167_ _168_ VGND VGND VPWR VPWR _169_ sky130_fd_sc_hd__nand3_1
X_482_ _084_ _072_ net10 _086_ VGND VGND VPWR VPWR _102_ sky130_fd_sc_hd__a22o_1
X_818_ mult_reg\[10\] net19 VGND VGND VPWR VPWR _416_ sky130_fd_sc_hd__or2_1
X_749_ _338_ _359_ VGND VGND VPWR VPWR _360_ sky130_fd_sc_hd__xnor2_1
XFILLER_0_0_195 VGND VGND VPWR VPWR sky130_fd_sc_hd__fill_1
XFILLER_0_28_91 VGND VGND VPWR VPWR sky130_fd_sc_hd__fill_1
XFILLER_0_8_251 VGND VGND VPWR VPWR sky130_fd_sc_hd__fill_1
XFILLER_0_39_143 VGND VGND VPWR VPWR sky130_fd_sc_hd__fill_2
XFILLER_0_39_121 VGND VGND VPWR VPWR sky130_fd_sc_hd__fill_2
X_465_ net4 VGND VGND VPWR VPWR _085_ sky130_fd_sc_hd__buf_6
X_534_ net16 VGND VGND VPWR VPWR _152_ sky130_fd_sc_hd__buf_2
X_603_ _087_ _145_ _191_ _190_ VGND VGND VPWR VPWR _219_ sky130_fd_sc_hd__a31o_1
XFILLER_0_40_15 VPWR VGND VPWR VGND sky130_ef_sc_hd__decap_12
XFILLER_0_4_15 VPWR VGND VPWR VGND sky130_ef_sc_hd__decap_12
XFILLER_0_45_113 VPWR VGND VPWR VGND sky130_ef_sc_hd__decap_12
XFILLER_0_30_81 VGND VGND VPWR VPWR sky130_fd_sc_hd__decap_3
XTAP_293 VGND VPWR sky130_fd_sc_hd__tapvpwrvgnd_1
XTAP_282 VGND VPWR sky130_fd_sc_hd__tapvpwrvgnd_1
XTAP_271 VGND VPWR sky130_fd_sc_hd__tapvpwrvgnd_1
XTAP_260 VGND VPWR sky130_fd_sc_hd__tapvpwrvgnd_1
XFILLER_0_10_29 VPWR VGND VPWR VGND sky130_ef_sc_hd__decap_12
XFILLER_0_35_15 VPWR VGND VPWR VGND sky130_ef_sc_hd__decap_12
X_448_ net11 net4 net3 net10 VGND VGND VPWR VPWR _068_ sky130_fd_sc_hd__nand4_2
X_517_ _133_ _134_ _081_ VGND VGND VPWR VPWR _136_ sky130_fd_sc_hd__a21oi_1
XFILLER_0_27_113 VGND VGND VPWR VPWR sky130_fd_sc_hd__fill_2
XFILLER_0_25_81 VGND VGND VPWR VPWR sky130_fd_sc_hd__decap_8
XFILLER_0_41_193 VPWR VGND VPWR VGND sky130_ef_sc_hd__decap_12
XFILLER_0_1_27 VPWR VGND VPWR VGND sky130_ef_sc_hd__decap_12
XFILLER_0_11_72 VGND VGND VPWR VPWR sky130_fd_sc_hd__decap_8
XFILLER_0_11_94 VGND VGND VPWR VPWR sky130_fd_sc_hd__decap_8
XFILLER_0_15_149 VPWR VGND VPWR VGND sky130_ef_sc_hd__decap_12
XFILLER_0_39_3 VPWR VGND VPWR VGND sky130_ef_sc_hd__decap_12
X_851_ _104_ _112_ _439_ VGND VGND VPWR VPWR _440_ sky130_fd_sc_hd__and3b_1
X_782_ mult_reg\[3\] net27 VGND VGND VPWR VPWR _387_ sky130_fd_sc_hd__nor2_1
XFILLER_0_32_16 VPWR VGND VPWR VGND sky130_ef_sc_hd__decap_12
XFILLER_0_20_141 VGND VGND VPWR VPWR sky130_fd_sc_hd__decap_8
XFILLER_0_7_113 VPWR VGND VPWR VGND sky130_ef_sc_hd__decap_12
XFILLER_0_28_263 VPWR VGND VPWR VGND sky130_ef_sc_hd__decap_12
Xoutput19 net19 VGND VGND VPWR VPWR accumulator[10] sky130_fd_sc_hd__clkbuf_4
X_834_ _427_ _428_ VGND VGND VPWR VPWR _429_ sky130_fd_sc_hd__and2b_1
X_903_ clknet_2_0__leaf_clk _006_ _047_ VGND VGND VPWR VPWR net24 sky130_fd_sc_hd__dfrtp_1
XFILLER_0_43_15 VPWR VGND VPWR VGND sky130_ef_sc_hd__decap_12
XPHY_5 VGND VGND VPWR VPWR sky130_fd_sc_hd__decap_3
X_696_ _302_ _281_ VGND VGND VPWR VPWR _309_ sky130_fd_sc_hd__and2b_1
X_765_ _372_ _374_ VGND VGND VPWR VPWR _025_ sky130_fd_sc_hd__xnor2_1
XFILLER_0_25_211 VGND VGND VPWR VPWR sky130_fd_sc_hd__decap_8
XFILLER_0_25_233 VPWR VGND VPWR VGND sky130_ef_sc_hd__decap_12
XFILLER_0_7_15 VPWR VGND VPWR VGND sky130_ef_sc_hd__decap_12
XFILLER_0_16_277 VPWR VGND VPWR VGND sky130_ef_sc_hd__decap_12
XFILLER_0_31_225 VPWR VGND VPWR VGND sky130_ef_sc_hd__decap_12
XFILLER_0_3_193 VPWR VGND VPWR VGND sky130_ef_sc_hd__decap_12
X_481_ _073_ VGND VGND VPWR VPWR _101_ sky130_fd_sc_hd__inv_2
X_550_ _164_ _165_ _166_ VGND VGND VPWR VPWR _168_ sky130_fd_sc_hd__a21o_1
XFILLER_0_38_15 VPWR VGND VPWR VGND sky130_ef_sc_hd__decap_12
X_817_ mult_reg\[10\] net19 VGND VGND VPWR VPWR _415_ sky130_fd_sc_hd__nand2_1
X_679_ _086_ _152_ VGND VGND VPWR VPWR _293_ sky130_fd_sc_hd__nand2_1
X_748_ _356_ _358_ VGND VGND VPWR VPWR _359_ sky130_fd_sc_hd__nand2_1
X_602_ _187_ _206_ VGND VGND VPWR VPWR _218_ sky130_fd_sc_hd__and2_1
X_464_ net11 VGND VGND VPWR VPWR _084_ sky130_fd_sc_hd__buf_2
X_533_ _084_ net6 VGND VGND VPWR VPWR _151_ sky130_fd_sc_hd__nand2_1
XFILLER_0_40_27 VGND VGND VPWR VPWR sky130_fd_sc_hd__fill_1
XFILLER_0_4_27 VGND VGND VPWR VPWR sky130_fd_sc_hd__fill_1
XFILLER_0_45_169 VPWR VGND VPWR VGND sky130_ef_sc_hd__decap_12
XFILLER_0_45_125 VPWR VGND VPWR VGND sky130_ef_sc_hd__decap_12
XFILLER_0_30_60 VGND VGND VPWR VPWR sky130_fd_sc_hd__decap_8
XTAP_294 VGND VPWR sky130_fd_sc_hd__tapvpwrvgnd_1
XTAP_283 VGND VPWR sky130_fd_sc_hd__tapvpwrvgnd_1
XTAP_272 VGND VPWR sky130_fd_sc_hd__tapvpwrvgnd_1
XTAP_261 VGND VPWR sky130_fd_sc_hd__tapvpwrvgnd_1
XTAP_250 VGND VPWR sky130_fd_sc_hd__tapvpwrvgnd_1
XFILLER_0_36_147 VGND VGND VPWR VPWR sky130_fd_sc_hd__fill_1
XFILLER_0_35_27 VGND VGND VPWR VPWR sky130_fd_sc_hd__decap_8
X_447_ net12 net2 VGND VGND VPWR VPWR _067_ sky130_fd_sc_hd__and2_1
X_516_ _081_ _133_ _134_ VGND VGND VPWR VPWR _135_ sky130_fd_sc_hd__and3_4
XFILLER_0_27_169 VGND VGND VPWR VPWR sky130_fd_sc_hd__decap_4
XFILLER_0_42_139 VGND VGND VPWR VPWR sky130_fd_sc_hd__fill_1
XFILLER_0_41_81 VPWR VGND VPWR VGND sky130_ef_sc_hd__decap_12
XFILLER_0_41_161 VGND VGND VPWR VPWR sky130_fd_sc_hd__decap_6
XFILLER_0_5_81 VPWR VGND VPWR VGND sky130_ef_sc_hd__decap_12
XFILLER_0_32_161 VPWR VGND VPWR VGND sky130_ef_sc_hd__decap_12
XFILLER_0_24_139 VGND VGND VPWR VPWR sky130_fd_sc_hd__fill_1
XFILLER_0_46_15 VGND VGND VPWR VPWR sky130_fd_sc_hd__fill_2
XFILLER_0_1_39 VPWR VGND VPWR VGND sky130_ef_sc_hd__decap_12
XFILLER_0_23_150 VPWR VGND VPWR VGND sky130_ef_sc_hd__decap_12
XFILLER_0_38_209 VPWR VGND VPWR VGND sky130_ef_sc_hd__decap_12
XFILLER_0_46_253 VPWR VGND VPWR VGND sky130_ef_sc_hd__decap_12
X_850_ _107_ _103_ _111_ VGND VGND VPWR VPWR _439_ sky130_fd_sc_hd__or3_1
X_781_ _382_ _383_ _384_ VGND VGND VPWR VPWR _386_ sky130_fd_sc_hd__o21a_1
XFILLER_0_16_29 VGND VGND VPWR VPWR sky130_fd_sc_hd__decap_3
XFILLER_0_29_209 VPWR VGND VPWR VGND sky130_ef_sc_hd__decap_12
XFILLER_0_43_223 VGND VGND VPWR VPWR sky130_fd_sc_hd__fill_1
XFILLER_0_7_169 VPWR VGND VPWR VGND sky130_ef_sc_hd__decap_12
XFILLER_0_7_125 VPWR VGND VPWR VGND sky130_ef_sc_hd__decap_12
XFILLER_0_28_275 VGND VGND VPWR VPWR sky130_fd_sc_hd__fill_1
XFILLER_0_11_120 VPWR VGND VPWR VGND sky130_ef_sc_hd__decap_12
XFILLER_0_11_164 VGND VGND VPWR VPWR sky130_fd_sc_hd__decap_4
X_833_ mult_reg\[13\] net22 VGND VGND VPWR VPWR _428_ sky130_fd_sc_hd__nand2_1
X_902_ clknet_2_1__leaf_clk _005_ _046_ VGND VGND VPWR VPWR net23 sky130_fd_sc_hd__dfrtp_2
XFILLER_0_27_28 VGND VGND VPWR VPWR sky130_fd_sc_hd__fill_1
X_764_ _353_ _373_ _365_ VGND VGND VPWR VPWR _374_ sky130_fd_sc_hd__o21ai_1
XFILLER_0_43_27 VPWR VGND VPWR VGND sky130_ef_sc_hd__decap_12
XPHY_6 VGND VGND VPWR VPWR sky130_fd_sc_hd__decap_3
X_695_ _306_ _308_ VGND VGND VPWR VPWR _021_ sky130_fd_sc_hd__xor2_1
XFILLER_0_7_27 VPWR VGND VPWR VGND sky130_ef_sc_hd__decap_12
XFILLER_0_4_139 VGND VGND VPWR VPWR sky130_fd_sc_hd__fill_1
XFILLER_0_25_245 VPWR VGND VPWR VGND sky130_ef_sc_hd__decap_12
XFILLER_0_17_83 VGND VGND VPWR VPWR sky130_fd_sc_hd__fill_1
XFILLER_0_3_161 VGND VGND VPWR VPWR sky130_fd_sc_hd__decap_6
XFILLER_0_16_289 VGND VGND VPWR VPWR sky130_fd_sc_hd__decap_8
XFILLER_0_31_215 VGND VGND VPWR VPWR sky130_fd_sc_hd__decap_8
XFILLER_0_31_237 VPWR VGND VPWR VGND sky130_ef_sc_hd__decap_12
X_480_ _075_ _074_ _066_ VGND VGND VPWR VPWR _100_ sky130_fd_sc_hd__o21ai_1
XFILLER_0_38_27 VGND VGND VPWR VPWR sky130_fd_sc_hd__fill_1
X_816_ _410_ _411_ _412_ VGND VGND VPWR VPWR _414_ sky130_fd_sc_hd__o21a_1
X_747_ _188_ _181_ _357_ VGND VGND VPWR VPWR _358_ sky130_fd_sc_hd__nand3_1
X_678_ _289_ _291_ VGND VGND VPWR VPWR _292_ sky130_fd_sc_hd__nand2_1
XFILLER_0_0_175 VPWR VGND VPWR VGND sky130_ef_sc_hd__decap_12
XFILLER_0_0_197 VPWR VGND VPWR VGND sky130_ef_sc_hd__decap_12
XFILLER_0_21_281 VPWR VGND VPWR VGND sky130_ef_sc_hd__decap_12
XFILLER_0_28_71 VPWR VGND VPWR VGND sky130_ef_sc_hd__decap_12
XFILLER_0_14_3 VPWR VGND VPWR VGND sky130_ef_sc_hd__decap_12
XFILLER_0_8_297 VGND VGND VPWR VPWR sky130_fd_sc_hd__fill_2
XFILLER_0_8_253 VPWR VGND VPWR VGND sky130_ef_sc_hd__decap_12
X_601_ _205_ _204_ VGND VGND VPWR VPWR _217_ sky130_fd_sc_hd__and2b_1
XFILLER_0_39_167 VGND VGND VPWR VPWR sky130_fd_sc_hd__fill_1
X_463_ _072_ _064_ VGND VGND VPWR VPWR _083_ sky130_fd_sc_hd__and2_1
XFILLER_0_24_29 VPWR VGND VPWR VGND sky130_ef_sc_hd__decap_12
X_532_ _148_ _149_ VGND VGND VPWR VPWR _150_ sky130_fd_sc_hd__nor2_1
XFILLER_0_45_137 VPWR VGND VPWR VGND sky130_ef_sc_hd__decap_12
XFILLER_0_5_223 VGND VGND VPWR VPWR sky130_fd_sc_hd__fill_1
XTAP_295 VGND VPWR sky130_fd_sc_hd__tapvpwrvgnd_1
XTAP_284 VGND VPWR sky130_fd_sc_hd__tapvpwrvgnd_1
XTAP_273 VGND VPWR sky130_fd_sc_hd__tapvpwrvgnd_1
XTAP_262 VGND VPWR sky130_fd_sc_hd__tapvpwrvgnd_1
XTAP_240 VGND VPWR sky130_fd_sc_hd__tapvpwrvgnd_1
XTAP_251 VGND VPWR sky130_fd_sc_hd__tapvpwrvgnd_1
XFILLER_0_3_3 VPWR VGND VPWR VGND sky130_ef_sc_hd__decap_12
X_515_ _130_ _131_ _132_ VGND VGND VPWR VPWR _134_ sky130_fd_sc_hd__a21o_1
X_446_ _064_ _065_ VGND VGND VPWR VPWR _066_ sky130_fd_sc_hd__nand2_1
XFILLER_0_35_181 VPWR VGND VPWR VGND sky130_ef_sc_hd__decap_12
XFILLER_0_18_126 VGND VGND VPWR VPWR sky130_fd_sc_hd__fill_1
XFILLER_0_41_93 VPWR VGND VPWR VGND sky130_ef_sc_hd__decap_12
XFILLER_0_18_148 VPWR VGND VPWR VGND sky130_ef_sc_hd__decap_12
XFILLER_0_1_281 VPWR VGND VPWR VGND sky130_ef_sc_hd__decap_12
XFILLER_0_5_93 VPWR VGND VPWR VGND sky130_ef_sc_hd__decap_12
XFILLER_0_32_195 VGND VGND VPWR VPWR sky130_fd_sc_hd__fill_1
XFILLER_0_32_173 VGND VGND VPWR VPWR sky130_fd_sc_hd__decap_6
XFILLER_0_46_27 VGND VGND VPWR VPWR sky130_fd_sc_hd__fill_1
XFILLER_0_23_162 VGND VGND VPWR VPWR sky130_fd_sc_hd__decap_6
XFILLER_0_36_93 VGND VGND VPWR VPWR sky130_fd_sc_hd__fill_2
XFILLER_0_36_71 VPWR VGND VPWR VGND sky130_ef_sc_hd__decap_12
Xinput1 activation[0] VGND VGND VPWR VPWR net1 sky130_fd_sc_hd__clkbuf_2
XFILLER_0_46_265 VPWR VGND VPWR VGND sky130_ef_sc_hd__decap_12
XFILLER_0_46_287 VGND VGND VPWR VPWR sky130_fd_sc_hd__decap_3
X_780_ _382_ _385_ VGND VGND VPWR VPWR _008_ sky130_fd_sc_hd__xnor2_1
XFILLER_0_32_29 VPWR VGND VPWR VGND sky130_ef_sc_hd__decap_12
XFILLER_0_37_221 VGND VGND VPWR VPWR sky130_fd_sc_hd__decap_3
XFILLER_0_7_137 VPWR VGND VPWR VGND sky130_ef_sc_hd__decap_12
XFILLER_0_43_279 VGND VGND VPWR VPWR sky130_fd_sc_hd__fill_1
XFILLER_0_11_132 VPWR VGND VPWR VGND sky130_ef_sc_hd__decap_12
XFILLER_0_28_287 VPWR VGND VPWR VGND sky130_ef_sc_hd__decap_12
XFILLER_0_44_3 VPWR VGND VPWR VGND sky130_ef_sc_hd__decap_12
XFILLER_0_2_83 VGND VGND VPWR VPWR sky130_fd_sc_hd__fill_1
XFILLER_0_34_268 VGND VGND VPWR VPWR sky130_fd_sc_hd__decap_4
XFILLER_0_34_224 VGND VGND VPWR VPWR sky130_fd_sc_hd__fill_2
XFILLER_0_19_254 VPWR VGND VPWR VGND sky130_ef_sc_hd__decap_12
X_901_ clknet_2_1__leaf_clk _004_ _045_ VGND VGND VPWR VPWR net22 sky130_fd_sc_hd__dfrtp_1
X_832_ mult_reg\[13\] net22 VGND VGND VPWR VPWR _427_ sky130_fd_sc_hd__nor2_1
X_763_ _347_ _367_ VGND VGND VPWR VPWR _373_ sky130_fd_sc_hd__or2_1
X_694_ _250_ _251_ _277_ _307_ VGND VGND VPWR VPWR _308_ sky130_fd_sc_hd__a31o_1
XFILLER_0_43_39 VPWR VGND VPWR VGND sky130_ef_sc_hd__decap_12
XPHY_7 VGND VGND VPWR VPWR sky130_fd_sc_hd__decap_3
XFILLER_0_7_39 VPWR VGND VPWR VGND sky130_ef_sc_hd__decap_12
XFILLER_0_25_257 VGND VGND VPWR VPWR sky130_fd_sc_hd__fill_2
XFILLER_0_16_224 VGND VGND VPWR VPWR sky130_fd_sc_hd__decap_8
XFILLER_0_31_249 VPWR VGND VPWR VGND sky130_ef_sc_hd__decap_12
X_815_ _410_ _413_ VGND VGND VPWR VPWR _015_ sky130_fd_sc_hd__xnor2_1
X_677_ _290_ VGND VGND VPWR VPWR _291_ sky130_fd_sc_hd__inv_2
X_746_ _152_ _147_ VGND VGND VPWR VPWR _357_ sky130_fd_sc_hd__and2_1
XFILLER_0_0_187 VGND VGND VPWR VPWR sky130_fd_sc_hd__decap_8
XFILLER_0_21_293 VGND VGND VPWR VPWR sky130_fd_sc_hd__decap_6
XFILLER_0_28_83 VGND VGND VPWR VPWR sky130_fd_sc_hd__fill_1
XFILLER_0_8_221 VPWR VGND VPWR VGND sky130_ef_sc_hd__decap_12
XFILLER_0_8_265 VPWR VGND VPWR VGND sky130_ef_sc_hd__decap_12
X_600_ _084_ _147_ _182_ VGND VGND VPWR VPWR _216_ sky130_fd_sc_hd__and3_1
X_531_ _079_ _147_ _118_ _146_ VGND VGND VPWR VPWR _149_ sky130_fd_sc_hd__a211oi_1
XFILLER_0_39_113 VGND VGND VPWR VPWR sky130_fd_sc_hd__decap_8
XFILLER_0_40_29 VPWR VGND VPWR VGND sky130_ef_sc_hd__decap_12
X_462_ _080_ _081_ VGND VGND VPWR VPWR _082_ sky130_fd_sc_hd__nor2_1
XFILLER_0_4_29 VPWR VGND VPWR VGND sky130_ef_sc_hd__decap_12
XFILLER_0_14_52 VPWR VGND VPWR VGND sky130_ef_sc_hd__decap_12
X_729_ _333_ _321_ _340_ VGND VGND VPWR VPWR _341_ sky130_fd_sc_hd__or3_1
XFILLER_0_45_149 VPWR VGND VPWR VGND sky130_ef_sc_hd__decap_12
XFILLER_0_45_105 VGND VGND VPWR VPWR sky130_fd_sc_hd__decap_6
XFILLER_0_5_279 VGND VGND VPWR VPWR sky130_fd_sc_hd__fill_1
XFILLER_0_30_73 VGND VGND VPWR VPWR sky130_fd_sc_hd__decap_8
XTAP_230 VGND VPWR sky130_fd_sc_hd__tapvpwrvgnd_1
XTAP_241 VGND VPWR sky130_fd_sc_hd__tapvpwrvgnd_1
XTAP_296 VGND VPWR sky130_fd_sc_hd__tapvpwrvgnd_1
XTAP_285 VGND VPWR sky130_fd_sc_hd__tapvpwrvgnd_1
XTAP_274 VGND VPWR sky130_fd_sc_hd__tapvpwrvgnd_1
XTAP_263 VGND VPWR sky130_fd_sc_hd__tapvpwrvgnd_1
XTAP_252 VGND VPWR sky130_fd_sc_hd__tapvpwrvgnd_1
XFILLER_0_36_138 VGND VGND VPWR VPWR sky130_fd_sc_hd__fill_2
X_514_ _130_ _131_ _132_ VGND VGND VPWR VPWR _133_ sky130_fd_sc_hd__nand3_1
X_445_ net1 VGND VGND VPWR VPWR _065_ sky130_fd_sc_hd__buf_2
XFILLER_0_35_193 VGND VGND VPWR VPWR sky130_fd_sc_hd__fill_2
XFILLER_0_18_138 VGND VGND VPWR VPWR sky130_fd_sc_hd__fill_2
XFILLER_0_1_293 VGND VGND VPWR VPWR sky130_fd_sc_hd__decap_6
XFILLER_0_46_7 VGND VGND VPWR VPWR sky130_fd_sc_hd__decap_8
XFILLER_0_36_83 VGND VGND VPWR VPWR sky130_fd_sc_hd__fill_1
Xinput2 activation[1] VGND VGND VPWR VPWR net2 sky130_fd_sc_hd__buf_1
XFILLER_0_46_277 VGND VGND VPWR VPWR sky130_fd_sc_hd__decap_3
XFILLER_0_14_152 VPWR VGND VPWR VGND sky130_ef_sc_hd__decap_12
XFILLER_0_20_177 VPWR VGND VPWR VGND sky130_ef_sc_hd__decap_12
XFILLER_0_43_225 VPWR VGND VPWR VGND sky130_ef_sc_hd__decap_12
XFILLER_0_7_149 VPWR VGND VPWR VGND sky130_ef_sc_hd__decap_12
XFILLER_0_7_105 VGND VGND VPWR VPWR sky130_fd_sc_hd__decap_6
XFILLER_0_22_41 VGND VGND VPWR VPWR sky130_fd_sc_hd__decap_8
XFILLER_0_11_111 VGND VGND VPWR VPWR sky130_fd_sc_hd__fill_1
XFILLER_0_11_144 VGND VGND VPWR VPWR sky130_fd_sc_hd__fill_2
XFILLER_0_37_3 VPWR VGND VPWR VGND sky130_ef_sc_hd__decap_12
XFILLER_0_19_200 VPWR VGND VPWR VGND sky130_ef_sc_hd__decap_12
XFILLER_0_19_266 VPWR VGND VPWR VGND sky130_ef_sc_hd__decap_12
X_900_ clknet_2_1__leaf_clk _003_ _044_ VGND VGND VPWR VPWR net21 sky130_fd_sc_hd__dfrtp_2
X_831_ _422_ _423_ _424_ VGND VGND VPWR VPWR _426_ sky130_fd_sc_hd__o21a_1
X_762_ _370_ _371_ VGND VGND VPWR VPWR _372_ sky130_fd_sc_hd__xor2_1
X_693_ _248_ _275_ _276_ VGND VGND VPWR VPWR _307_ sky130_fd_sc_hd__o21ba_1
XPHY_8 VGND VGND VPWR VPWR sky130_fd_sc_hd__decap_3
XFILLER_0_33_51 VGND VGND VPWR VPWR sky130_fd_sc_hd__decap_4
X_814_ _411_ _412_ VGND VGND VPWR VPWR _413_ sky130_fd_sc_hd__and2b_1
XFILLER_0_38_29 VPWR VGND VPWR VGND sky130_ef_sc_hd__decap_12
X_676_ _078_ _116_ net6 _152_ VGND VGND VPWR VPWR _290_ sky130_fd_sc_hd__and4_1
X_745_ _147_ _188_ _181_ _152_ VGND VGND VPWR VPWR _356_ sky130_fd_sc_hd__a22o_1
XFILLER_0_0_133 VGND VGND VPWR VPWR sky130_fd_sc_hd__decap_3
XFILLER_0_44_83 VGND VGND VPWR VPWR sky130_fd_sc_hd__fill_1
XFILLER_0_8_233 VPWR VGND VPWR VGND sky130_ef_sc_hd__decap_12
XFILLER_0_8_277 VPWR VGND VPWR VGND sky130_ef_sc_hd__decap_12
XFILLER_0_8_83 VGND VGND VPWR VPWR sky130_fd_sc_hd__fill_1
X_461_ net10 _065_ _077_ _078_ VGND VGND VPWR VPWR _081_ sky130_fd_sc_hd__and4_1
X_530_ _118_ _146_ _079_ _147_ VGND VGND VPWR VPWR _148_ sky130_fd_sc_hd__o211a_1
XFILLER_0_39_169 VPWR VGND VPWR VGND sky130_ef_sc_hd__decap_12
XFILLER_0_14_64 VPWR VGND VPWR VGND sky130_ef_sc_hd__decap_12
X_728_ _338_ _339_ VGND VGND VPWR VPWR _340_ sky130_fd_sc_hd__nor2_1
X_659_ _252_ _273_ VGND VGND VPWR VPWR _274_ sky130_fd_sc_hd__xnor2_1
XFILLER_0_5_225 VPWR VGND VPWR VGND sky130_ef_sc_hd__decap_12
XFILLER_0_30_52 VGND VGND VPWR VPWR sky130_fd_sc_hd__fill_1
XTAP_275 VGND VPWR sky130_fd_sc_hd__tapvpwrvgnd_1
XTAP_264 VGND VPWR sky130_fd_sc_hd__tapvpwrvgnd_1
XTAP_220 VGND VPWR sky130_fd_sc_hd__tapvpwrvgnd_1
XTAP_231 VGND VPWR sky130_fd_sc_hd__tapvpwrvgnd_1
XTAP_242 VGND VPWR sky130_fd_sc_hd__tapvpwrvgnd_1
XTAP_253 VGND VPWR sky130_fd_sc_hd__tapvpwrvgnd_1
XTAP_297 VGND VPWR sky130_fd_sc_hd__tapvpwrvgnd_1
XTAP_286 VGND VPWR sky130_fd_sc_hd__tapvpwrvgnd_1
X_444_ net13 VGND VGND VPWR VPWR _064_ sky130_fd_sc_hd__buf_6
X_513_ _082_ _094_ _093_ VGND VGND VPWR VPWR _132_ sky130_fd_sc_hd__a21bo_1
XFILLER_0_42_109 VPWR VGND VPWR VGND sky130_ef_sc_hd__decap_12
XFILLER_0_25_41 VGND VGND VPWR VPWR sky130_fd_sc_hd__fill_2
XFILLER_0_41_51 VGND VGND VPWR VPWR sky130_fd_sc_hd__decap_4
XFILLER_0_1_261 VPWR VGND VPWR VGND sky130_ef_sc_hd__decap_12
XFILLER_0_26_194 VGND VGND VPWR VPWR sky130_fd_sc_hd__fill_2
XFILLER_0_5_51 VGND VGND VPWR VPWR sky130_fd_sc_hd__decap_4
XFILLER_0_32_120 VGND VGND VPWR VPWR sky130_fd_sc_hd__decap_3
XFILLER_0_24_109 VPWR VGND VPWR VGND sky130_ef_sc_hd__decap_12
XFILLER_0_32_197 VPWR VGND VPWR VGND sky130_ef_sc_hd__decap_12
XFILLER_0_46_29 VPWR VGND VPWR VGND sky130_ef_sc_hd__decap_12
Xinput3 activation[2] VGND VGND VPWR VPWR net3 sky130_fd_sc_hd__buf_8
XFILLER_0_46_223 VGND VGND VPWR VPWR sky130_fd_sc_hd__fill_1
XFILLER_0_14_186 VGND VGND VPWR VPWR sky130_fd_sc_hd__fill_2
XFILLER_0_37_201 VPWR VGND VPWR VGND sky130_ef_sc_hd__decap_12
XFILLER_0_20_123 VGND VGND VPWR VPWR sky130_fd_sc_hd__decap_4
XFILLER_0_20_134 VGND VGND VPWR VPWR sky130_fd_sc_hd__fill_1
XFILLER_0_20_156 VGND VGND VPWR VPWR sky130_fd_sc_hd__decap_8
XFILLER_0_20_189 VGND VGND VPWR VPWR sky130_fd_sc_hd__decap_6
XFILLER_0_43_237 VPWR VGND VPWR VGND sky130_ef_sc_hd__decap_12
XFILLER_0_28_212 VGND VGND VPWR VPWR sky130_fd_sc_hd__fill_2
XFILLER_0_2_41 VPWR VGND VPWR VGND sky130_ef_sc_hd__decap_12
XFILLER_0_2_85 VPWR VGND VPWR VGND sky130_ef_sc_hd__decap_12
XFILLER_0_19_212 VPWR VGND VPWR VGND sky130_ef_sc_hd__decap_12
XFILLER_0_19_278 VGND VGND VPWR VPWR sky130_fd_sc_hd__fill_2
X_830_ _422_ _425_ VGND VGND VPWR VPWR _003_ sky130_fd_sc_hd__xnor2_1
X_761_ _188_ _181_ _335_ VGND VGND VPWR VPWR _371_ sky130_fd_sc_hd__and3_1
XPHY_9 VGND VGND VPWR VPWR sky130_fd_sc_hd__decap_3
X_692_ _304_ _305_ VGND VGND VPWR VPWR _306_ sky130_fd_sc_hd__nor2_1
XFILLER_0_4_109 VPWR VGND VPWR VGND sky130_ef_sc_hd__decap_12
XFILLER_0_17_42 VGND VGND VPWR VPWR sky130_fd_sc_hd__fill_2
XFILLER_0_16_9 VPWR VGND VPWR VGND sky130_ef_sc_hd__decap_12
XFILLER_0_31_207 VGND VGND VPWR VPWR sky130_fd_sc_hd__fill_1
XFILLER_0_15_281 VPWR VGND VPWR VGND sky130_ef_sc_hd__decap_12
XFILLER_0_22_207 VPWR VGND VPWR VGND sky130_ef_sc_hd__decap_12
XFILLER_0_30_251 VGND VGND VPWR VPWR sky130_fd_sc_hd__fill_1
X_813_ mult_reg\[9\] net33 VGND VGND VPWR VPWR _412_ sky130_fd_sc_hd__nand2_1
X_744_ _343_ _345_ VGND VGND VPWR VPWR _355_ sky130_fd_sc_hd__nand2_1
X_675_ _116_ _145_ _152_ _078_ VGND VGND VPWR VPWR _289_ sky130_fd_sc_hd__a22o_1
XFILLER_0_0_167 VGND VGND VPWR VPWR sky130_fd_sc_hd__fill_1
XFILLER_0_21_251 VPWR VGND VPWR VGND sky130_ef_sc_hd__decap_12
XFILLER_0_28_41 VGND VGND VPWR VPWR sky130_fd_sc_hd__decap_4
XFILLER_0_21_7 VGND VGND VPWR VPWR sky130_fd_sc_hd__decap_4
XFILLER_0_28_85 VGND VGND VPWR VPWR sky130_fd_sc_hd__decap_6
XFILLER_0_8_245 VGND VGND VPWR VPWR sky130_fd_sc_hd__decap_6
XFILLER_0_8_289 VGND VGND VPWR VPWR sky130_fd_sc_hd__decap_8
XFILLER_0_12_251 VGND VGND VPWR VPWR sky130_fd_sc_hd__fill_1
X_460_ _065_ _077_ _078_ _079_ VGND VGND VPWR VPWR _080_ sky130_fd_sc_hd__a22oi_1
X_727_ _145_ _188_ _337_ VGND VGND VPWR VPWR _339_ sky130_fd_sc_hd__a21oi_1
XFILLER_0_14_76 VGND VGND VPWR VPWR sky130_fd_sc_hd__decap_8
X_589_ _204_ _205_ VGND VGND VPWR VPWR _206_ sky130_fd_sc_hd__xnor2_1
X_658_ _271_ _272_ VGND VGND VPWR VPWR _273_ sky130_fd_sc_hd__xnor2_1
XFILLER_0_5_237 VPWR VGND VPWR VGND sky130_ef_sc_hd__decap_12
XTAP_298 VGND VPWR sky130_fd_sc_hd__tapvpwrvgnd_1
XFILLER_0_39_51 VGND VGND VPWR VPWR sky130_fd_sc_hd__decap_4
XTAP_287 VGND VPWR sky130_fd_sc_hd__tapvpwrvgnd_1
XTAP_276 VGND VPWR sky130_fd_sc_hd__tapvpwrvgnd_1
XTAP_265 VGND VPWR sky130_fd_sc_hd__tapvpwrvgnd_1
XTAP_210 VGND VPWR sky130_fd_sc_hd__tapvpwrvgnd_1
XTAP_221 VGND VPWR sky130_fd_sc_hd__tapvpwrvgnd_1
XTAP_232 VGND VPWR sky130_fd_sc_hd__tapvpwrvgnd_1
XTAP_243 VGND VPWR sky130_fd_sc_hd__tapvpwrvgnd_1
XTAP_254 VGND VPWR sky130_fd_sc_hd__tapvpwrvgnd_1
XFILLER_0_12_3 VPWR VGND VPWR VGND sky130_ef_sc_hd__decap_12
XFILLER_0_36_118 VPWR VGND VPWR VGND sky130_ef_sc_hd__decap_12
XFILLER_0_44_195 VGND VGND VPWR VPWR sky130_fd_sc_hd__fill_1
X_512_ _128_ _129_ _121_ VGND VGND VPWR VPWR _131_ sky130_fd_sc_hd__a21o_1
XFILLER_0_26_173 VGND VGND VPWR VPWR sky130_fd_sc_hd__decap_3
XFILLER_0_1_273 VGND VGND VPWR VPWR sky130_fd_sc_hd__decap_6
XFILLER_0_32_154 VGND VGND VPWR VPWR sky130_fd_sc_hd__decap_4
XFILLER_0_17_140 VPWR VGND VPWR VGND sky130_ef_sc_hd__decap_12
XFILLER_0_32_187 VGND VGND VPWR VPWR sky130_fd_sc_hd__decap_8
XFILLER_0_1_3 VPWR VGND VPWR VGND sky130_ef_sc_hd__decap_12
Xinput4 activation[3] VGND VGND VPWR VPWR net4 sky130_fd_sc_hd__buf_6
XFILLER_0_36_85 VGND VGND VPWR VPWR sky130_fd_sc_hd__decap_8
Xclkbuf_2_1__f_clk clknet_0_clk VGND VGND VPWR VPWR clknet_2_1__leaf_clk sky130_fd_sc_hd__clkbuf_16
XFILLER_0_37_279 VGND VGND VPWR VPWR sky130_fd_sc_hd__fill_1
XFILLER_0_37_213 VGND VGND VPWR VPWR sky130_fd_sc_hd__decap_8
XFILLER_0_20_102 VGND VGND VPWR VPWR sky130_fd_sc_hd__decap_4
XFILLER_0_43_249 VPWR VGND VPWR VGND sky130_ef_sc_hd__decap_12
XFILLER_0_43_205 VPWR VGND VPWR VGND sky130_ef_sc_hd__decap_12
XFILLER_0_11_113 VGND VGND VPWR VPWR sky130_fd_sc_hd__fill_1
XFILLER_0_2_53 VPWR VGND VPWR VGND sky130_ef_sc_hd__decap_12
XFILLER_0_2_97 VPWR VGND VPWR VGND sky130_ef_sc_hd__decap_12
XFILLER_0_6_195 VGND VGND VPWR VPWR sky130_fd_sc_hd__fill_1
XFILLER_0_10_190 VGND VGND VPWR VPWR sky130_fd_sc_hd__decap_6
X_760_ _338_ _356_ _358_ _363_ VGND VGND VPWR VPWR _370_ sky130_fd_sc_hd__a31o_1
X_691_ _303_ _280_ VGND VGND VPWR VPWR _305_ sky130_fd_sc_hd__and2b_1
XFILLER_0_17_65 VPWR VGND VPWR VGND sky130_ef_sc_hd__decap_12
XFILLER_0_17_87 VPWR VGND VPWR VGND sky130_ef_sc_hd__decap_12
X_889_ clknet_2_0__leaf_clk _007_ _033_ VGND VGND VPWR VPWR net25 sky130_fd_sc_hd__dfrtp_1
XFILLER_0_16_238 VPWR VGND VPWR VGND sky130_ef_sc_hd__decap_12
XFILLER_0_15_293 VGND VGND VPWR VPWR sky130_fd_sc_hd__decap_6
X_812_ mult_reg\[9\] net33 VGND VGND VPWR VPWR _411_ sky130_fd_sc_hd__nor2_1
X_674_ _286_ _287_ VGND VGND VPWR VPWR _288_ sky130_fd_sc_hd__or2_1
X_743_ net34 _354_ VGND VGND VPWR VPWR _023_ sky130_fd_sc_hd__nor2_1
XFILLER_0_0_113 VPWR VGND VPWR VGND sky130_ef_sc_hd__decap_12
XFILLER_0_21_263 VPWR VGND VPWR VGND sky130_ef_sc_hd__decap_12
XFILLER_0_44_85 VPWR VGND VPWR VGND sky130_ef_sc_hd__decap_12
XFILLER_0_44_41 VPWR VGND VPWR VGND sky130_ef_sc_hd__decap_12
XFILLER_0_8_85 VPWR VGND VPWR VGND sky130_ef_sc_hd__decap_12
XFILLER_0_8_41 VPWR VGND VPWR VGND sky130_ef_sc_hd__decap_12
X_726_ _145_ _188_ _337_ VGND VGND VPWR VPWR _338_ sky130_fd_sc_hd__and3_1
X_657_ _225_ _241_ _240_ VGND VGND VPWR VPWR _272_ sky130_fd_sc_hd__a21boi_1
XFILLER_0_38_182 VPWR VGND VPWR VGND sky130_ef_sc_hd__decap_12
XFILLER_0_5_205 VPWR VGND VPWR VGND sky130_ef_sc_hd__decap_12
X_588_ _162_ _164_ VGND VGND VPWR VPWR _205_ sky130_fd_sc_hd__and2_1
XFILLER_0_30_32 VPWR VGND VPWR VGND sky130_ef_sc_hd__decap_12
XFILLER_0_5_249 VPWR VGND VPWR VGND sky130_ef_sc_hd__decap_12
XFILLER_0_30_98 VGND VGND VPWR VPWR sky130_fd_sc_hd__decap_4
XTAP_299 VGND VPWR sky130_fd_sc_hd__tapvpwrvgnd_1
XTAP_288 VGND VPWR sky130_fd_sc_hd__tapvpwrvgnd_1
XTAP_277 VGND VPWR sky130_fd_sc_hd__tapvpwrvgnd_1
XTAP_266 VGND VPWR sky130_fd_sc_hd__tapvpwrvgnd_1
XTAP_200 VGND VPWR sky130_fd_sc_hd__tapvpwrvgnd_1
XTAP_211 VGND VPWR sky130_fd_sc_hd__tapvpwrvgnd_1
XTAP_222 VGND VPWR sky130_fd_sc_hd__tapvpwrvgnd_1
XTAP_233 VGND VPWR sky130_fd_sc_hd__tapvpwrvgnd_1
XTAP_244 VGND VPWR sky130_fd_sc_hd__tapvpwrvgnd_1
XTAP_255 VGND VPWR sky130_fd_sc_hd__tapvpwrvgnd_1
XFILLER_0_44_141 VPWR VGND VPWR VGND sky130_ef_sc_hd__decap_12
X_511_ _121_ _128_ _129_ VGND VGND VPWR VPWR _130_ sky130_fd_sc_hd__nand3_1
X_709_ _320_ _321_ VGND VGND VPWR VPWR _322_ sky130_fd_sc_hd__or2_1
XFILLER_0_25_54 VGND VGND VPWR VPWR sky130_fd_sc_hd__fill_2
XFILLER_0_41_111 VGND VGND VPWR VPWR sky130_fd_sc_hd__fill_1
XFILLER_0_17_152 VGND VGND VPWR VPWR sky130_fd_sc_hd__decap_6
XFILLER_0_11_89 VGND VGND VPWR VPWR sky130_fd_sc_hd__fill_1
Xinput5 activation[4] VGND VGND VPWR VPWR net5 sky130_fd_sc_hd__buf_2
XFILLER_0_46_247 VGND VGND VPWR VPWR sky130_fd_sc_hd__decap_4
XFILLER_0_46_225 VPWR VGND VPWR VGND sky130_ef_sc_hd__decap_12
XTAP_94 VGND VPWR sky130_fd_sc_hd__tapvpwrvgnd_1
XFILLER_0_37_225 VPWR VGND VPWR VGND sky130_ef_sc_hd__decap_12
XFILLER_0_43_217 VGND VGND VPWR VPWR sky130_fd_sc_hd__decap_6
XFILLER_0_22_88 VGND VGND VPWR VPWR sky130_fd_sc_hd__decap_4
XFILLER_0_2_65 VPWR VGND VPWR VGND sky130_ef_sc_hd__decap_12
XFILLER_0_2_21 VGND VGND VPWR VPWR sky130_fd_sc_hd__decap_6
XFILLER_0_34_217 VGND VGND VPWR VPWR sky130_fd_sc_hd__decap_4
XFILLER_0_6_141 VPWR VGND VPWR VGND sky130_ef_sc_hd__decap_12
X_690_ _280_ _303_ VGND VGND VPWR VPWR _304_ sky130_fd_sc_hd__and2b_1
XFILLER_0_40_209 VPWR VGND VPWR VGND sky130_ef_sc_hd__decap_12
XFILLER_0_17_55 VGND VGND VPWR VPWR sky130_fd_sc_hd__fill_1
XFILLER_0_17_77 VGND VGND VPWR VPWR sky130_fd_sc_hd__decap_6
X_888_ clknet_2_0__leaf_clk _000_ _032_ VGND VGND VPWR VPWR net18 sky130_fd_sc_hd__dfrtp_4
XFILLER_0_3_111 VGND VGND VPWR VPWR sky130_fd_sc_hd__fill_1
XFILLER_0_35_3 VPWR VGND VPWR VGND sky130_ef_sc_hd__decap_12
XFILLER_0_15_250 VPWR VGND VPWR VGND sky130_ef_sc_hd__decap_12
X_811_ _406_ _407_ _408_ VGND VGND VPWR VPWR _410_ sky130_fd_sc_hd__o21a_1
X_673_ _283_ _285_ VGND VGND VPWR VPWR _287_ sky130_fd_sc_hd__nor2_1
X_742_ _349_ _352_ VGND VGND VPWR VPWR _354_ sky130_fd_sc_hd__and2_1
XFILLER_0_0_125 VGND VGND VPWR VPWR sky130_fd_sc_hd__decap_8
XFILLER_0_0_169 VGND VGND VPWR VPWR sky130_fd_sc_hd__fill_2
XFILLER_0_21_275 VGND VGND VPWR VPWR sky130_fd_sc_hd__decap_4
XFILLER_0_28_98 VPWR VGND VPWR VGND sky130_ef_sc_hd__decap_12
XFILLER_0_44_97 VPWR VGND VPWR VGND sky130_ef_sc_hd__decap_12
XFILLER_0_44_53 VPWR VGND VPWR VGND sky130_ef_sc_hd__decap_12
XFILLER_0_8_97 VPWR VGND VPWR VGND sky130_ef_sc_hd__decap_12
XFILLER_0_8_53 VPWR VGND VPWR VGND sky130_ef_sc_hd__decap_12
XFILLER_0_12_253 VPWR VGND VPWR VGND sky130_ef_sc_hd__decap_12
XFILLER_0_12_297 VGND VGND VPWR VPWR sky130_fd_sc_hd__fill_2
X_587_ _193_ _203_ VGND VGND VPWR VPWR _204_ sky130_fd_sc_hd__xor2_1
X_725_ _334_ _336_ VGND VGND VPWR VPWR _337_ sky130_fd_sc_hd__xor2_1
X_656_ _269_ _270_ VGND VGND VPWR VPWR _271_ sky130_fd_sc_hd__nand2_1
XFILLER_0_38_194 VGND VGND VPWR VPWR sky130_fd_sc_hd__fill_2
XFILLER_0_5_217 VGND VGND VPWR VPWR sky130_fd_sc_hd__decap_6
XFILLER_0_30_44 VGND VGND VPWR VPWR sky130_fd_sc_hd__decap_8
XTAP_201 VGND VPWR sky130_fd_sc_hd__tapvpwrvgnd_1
XTAP_212 VGND VPWR sky130_fd_sc_hd__tapvpwrvgnd_1
XTAP_223 VGND VPWR sky130_fd_sc_hd__tapvpwrvgnd_1
XTAP_289 VGND VPWR sky130_fd_sc_hd__tapvpwrvgnd_1
XTAP_278 VGND VPWR sky130_fd_sc_hd__tapvpwrvgnd_1
XTAP_267 VGND VPWR sky130_fd_sc_hd__tapvpwrvgnd_1
XTAP_234 VGND VPWR sky130_fd_sc_hd__tapvpwrvgnd_1
XTAP_245 VGND VPWR sky130_fd_sc_hd__tapvpwrvgnd_1
XTAP_256 VGND VPWR sky130_fd_sc_hd__tapvpwrvgnd_1
XFILLER_0_29_172 VGND VGND VPWR VPWR sky130_fd_sc_hd__decap_6
XFILLER_0_44_197 VPWR VGND VPWR VGND sky130_ef_sc_hd__decap_12
XFILLER_0_44_153 VPWR VGND VPWR VGND sky130_ef_sc_hd__decap_12
X_510_ _125_ _126_ _127_ VGND VGND VPWR VPWR _129_ sky130_fd_sc_hd__a21o_1
XFILLER_0_2_209 VPWR VGND VPWR VGND sky130_ef_sc_hd__decap_12
XFILLER_0_25_11 VGND VGND VPWR VPWR sky130_fd_sc_hd__fill_2
X_708_ _315_ _319_ VGND VGND VPWR VPWR _321_ sky130_fd_sc_hd__and2_1
X_639_ _064_ net7 VGND VGND VPWR VPWR _254_ sky130_fd_sc_hd__nand2_1
XFILLER_0_25_33 VGND VGND VPWR VPWR sky130_fd_sc_hd__decap_8
XFILLER_0_41_167 VGND VGND VPWR VPWR sky130_fd_sc_hd__fill_1
XFILLER_0_26_186 VGND VGND VPWR VPWR sky130_fd_sc_hd__decap_8
XFILLER_0_26_197 VGND VGND VPWR VPWR sky130_fd_sc_hd__decap_8
XFILLER_0_17_164 VGND VGND VPWR VPWR sky130_fd_sc_hd__decap_4
XFILLER_0_32_145 VGND VGND VPWR VPWR sky130_fd_sc_hd__decap_6
Xinput6 activation[5] VGND VGND VPWR VPWR net6 sky130_fd_sc_hd__buf_2
XFILLER_0_46_237 VGND VGND VPWR VPWR sky130_fd_sc_hd__decap_4
XTAP_95 VGND VPWR sky130_fd_sc_hd__tapvpwrvgnd_1
XFILLER_0_14_112 VGND VGND VPWR VPWR sky130_fd_sc_hd__decap_3
XFILLER_0_45_281 VPWR VGND VPWR VGND sky130_ef_sc_hd__decap_12
XFILLER_0_37_237 VPWR VGND VPWR VGND sky130_ef_sc_hd__decap_12
XPHY_90 VGND VGND VPWR VPWR sky130_fd_sc_hd__decap_3
XFILLER_0_22_23 VGND VGND VPWR VPWR sky130_fd_sc_hd__decap_4
XFILLER_0_22_67 VPWR VGND VPWR VGND sky130_ef_sc_hd__decap_12
XFILLER_0_28_204 VGND VGND VPWR VPWR sky130_fd_sc_hd__decap_8
XFILLER_0_28_237 VPWR VGND VPWR VGND sky130_ef_sc_hd__decap_12
XFILLER_0_2_77 VGND VGND VPWR VPWR sky130_fd_sc_hd__decap_6
XFILLER_0_6_153 VPWR VGND VPWR VGND sky130_ef_sc_hd__decap_12
XFILLER_0_27_281 VPWR VGND VPWR VGND sky130_ef_sc_hd__decap_12
XFILLER_0_42_251 VGND VGND VPWR VPWR sky130_fd_sc_hd__fill_1
XFILLER_0_6_197 VPWR VGND VPWR VGND sky130_ef_sc_hd__decap_12
XFILLER_0_33_284 VPWR VGND VPWR VGND sky130_ef_sc_hd__decap_12
XFILLER_0_17_34 VGND VGND VPWR VPWR sky130_fd_sc_hd__decap_8
X_887_ net9 VGND VGND VPWR VPWR _063_ sky130_fd_sc_hd__inv_2
XFILLER_0_33_55 VGND VGND VPWR VPWR sky130_fd_sc_hd__fill_1
XFILLER_0_3_167 VGND VGND VPWR VPWR sky130_fd_sc_hd__fill_1
XFILLER_0_24_251 VGND VGND VPWR VPWR sky130_fd_sc_hd__fill_1
XFILLER_0_24_273 VPWR VGND VPWR VGND sky130_ef_sc_hd__decap_12
XFILLER_0_15_262 VPWR VGND VPWR VGND sky130_ef_sc_hd__decap_12
X_810_ _406_ _409_ VGND VGND VPWR VPWR _014_ sky130_fd_sc_hd__xnor2_1
XFILLER_0_30_265 VPWR VGND VPWR VGND sky130_ef_sc_hd__decap_12
XFILLER_0_30_298 VGND VGND VPWR VPWR sky130_fd_sc_hd__fill_1
X_672_ _283_ _285_ VGND VGND VPWR VPWR _286_ sky130_fd_sc_hd__and2_1
X_741_ _349_ _352_ VGND VGND VPWR VPWR _353_ sky130_fd_sc_hd__nor2_2
XFILLER_0_0_104 VGND VGND VPWR VPWR sky130_fd_sc_hd__decap_8
XFILLER_0_44_65 VPWR VGND VPWR VGND sky130_ef_sc_hd__decap_12
XFILLER_0_8_65 VPWR VGND VPWR VGND sky130_ef_sc_hd__decap_12
XFILLER_0_12_221 VPWR VGND VPWR VGND sky130_ef_sc_hd__decap_12
XFILLER_0_12_265 VPWR VGND VPWR VGND sky130_ef_sc_hd__decap_12
XFILLER_0_7_281 VPWR VGND VPWR VGND sky130_ef_sc_hd__decap_12
X_724_ _147_ _335_ _312_ VGND VGND VPWR VPWR _336_ sky130_fd_sc_hd__mux2_1
X_586_ _201_ _202_ VGND VGND VPWR VPWR _203_ sky130_fd_sc_hd__nor2b_1
X_655_ _257_ _268_ VGND VGND VPWR VPWR _270_ sky130_fd_sc_hd__nand2_1
XTAP_202 VGND VPWR sky130_fd_sc_hd__tapvpwrvgnd_1
XTAP_213 VGND VPWR sky130_fd_sc_hd__tapvpwrvgnd_1
XTAP_224 VGND VPWR sky130_fd_sc_hd__tapvpwrvgnd_1
XTAP_235 VGND VPWR sky130_fd_sc_hd__tapvpwrvgnd_1
XTAP_246 VGND VPWR sky130_fd_sc_hd__tapvpwrvgnd_1
XTAP_257 VGND VPWR sky130_fd_sc_hd__tapvpwrvgnd_1
XTAP_279 VGND VPWR sky130_fd_sc_hd__tapvpwrvgnd_1
XTAP_268 VGND VPWR sky130_fd_sc_hd__tapvpwrvgnd_1
XFILLER_0_44_121 VPWR VGND VPWR VGND sky130_ef_sc_hd__decap_12
XFILLER_0_44_165 VPWR VGND VPWR VGND sky130_ef_sc_hd__decap_12
XFILLER_0_4_295 VGND VGND VPWR VPWR sky130_fd_sc_hd__fill_1
XFILLER_0_4_251 VGND VGND VPWR VPWR sky130_fd_sc_hd__fill_1
XFILLER_0_35_110 VGND VGND VPWR VPWR sky130_fd_sc_hd__fill_2
X_707_ _315_ _319_ VGND VGND VPWR VPWR _320_ sky130_fd_sc_hd__nor2_1
XFILLER_0_41_55 VGND VGND VPWR VPWR sky130_fd_sc_hd__fill_1
X_638_ _087_ net8 VGND VGND VPWR VPWR _253_ sky130_fd_sc_hd__nand2_1
X_569_ _079_ _181_ _184_ VGND VGND VPWR VPWR _186_ sky130_fd_sc_hd__a21oi_1
XFILLER_0_25_89 VGND VGND VPWR VPWR sky130_fd_sc_hd__fill_1
XFILLER_0_41_113 VPWR VGND VPWR VGND sky130_ef_sc_hd__decap_12
XFILLER_0_26_132 VGND VGND VPWR VPWR sky130_fd_sc_hd__fill_1
XFILLER_0_26_165 VGND VGND VPWR VPWR sky130_fd_sc_hd__decap_8
XFILLER_0_5_55 VGND VGND VPWR VPWR sky130_fd_sc_hd__fill_1
XFILLER_0_10_3 VPWR VGND VPWR VGND sky130_ef_sc_hd__decap_12
XFILLER_0_17_176 VPWR VGND VPWR VGND sky130_ef_sc_hd__decap_12
XFILLER_0_32_179 VGND VGND VPWR VPWR sky130_fd_sc_hd__fill_1
XFILLER_0_11_47 VGND VGND VPWR VPWR sky130_fd_sc_hd__fill_2
XFILLER_0_23_113 VPWR VGND VPWR VGND sky130_ef_sc_hd__decap_12
Xinput7 activation[6] VGND VGND VPWR VPWR net7 sky130_fd_sc_hd__clkbuf_4
XFILLER_0_46_205 VPWR VGND VPWR VGND sky130_ef_sc_hd__decap_12
XTAP_96 VGND VPWR sky130_fd_sc_hd__tapvpwrvgnd_1
XFILLER_0_37_249 VPWR VGND VPWR VGND sky130_ef_sc_hd__decap_12
XFILLER_0_45_293 VGND VGND VPWR VPWR sky130_fd_sc_hd__decap_6
XPHY_91 VGND VGND VPWR VPWR sky130_fd_sc_hd__decap_3
XPHY_80 VGND VGND VPWR VPWR sky130_fd_sc_hd__decap_3
XFILLER_0_11_105 VGND VGND VPWR VPWR sky130_fd_sc_hd__decap_6
XFILLER_0_6_165 VPWR VGND VPWR VGND sky130_ef_sc_hd__decap_12
XFILLER_0_6_121 VPWR VGND VPWR VGND sky130_ef_sc_hd__decap_12
XFILLER_0_27_293 VGND VGND VPWR VPWR sky130_fd_sc_hd__decap_6
XFILLER_0_33_296 VGND VGND VPWR VPWR sky130_fd_sc_hd__decap_3
X_886_ net9 VGND VGND VPWR VPWR _062_ sky130_fd_sc_hd__inv_2
Xinput10 weight[0] VGND VGND VPWR VPWR net10 sky130_fd_sc_hd__clkbuf_4
XFILLER_0_3_113 VPWR VGND VPWR VGND sky130_ef_sc_hd__decap_12
XFILLER_0_24_285 VGND VGND VPWR VPWR sky130_fd_sc_hd__decap_8
XFILLER_0_15_274 VGND VGND VPWR VPWR sky130_fd_sc_hd__decap_6
X_740_ _306_ _308_ _330_ _351_ VGND VGND VPWR VPWR _352_ sky130_fd_sc_hd__a31oi_2
XFILLER_0_30_277 VGND VGND VPWR VPWR sky130_fd_sc_hd__fill_1
X_671_ _284_ net7 _259_ VGND VGND VPWR VPWR _285_ sky130_fd_sc_hd__mux2_1
XFILLER_0_0_149 VPWR VGND VPWR VGND sky130_ef_sc_hd__decap_12
XFILLER_0_21_233 VGND VGND VPWR VPWR sky130_fd_sc_hd__fill_2
X_869_ _442_ VGND VGND VPWR VPWR _046_ sky130_fd_sc_hd__inv_2
XFILLER_0_44_77 VGND VGND VPWR VPWR sky130_fd_sc_hd__decap_6
XFILLER_0_8_77 VGND VGND VPWR VPWR sky130_fd_sc_hd__decap_6
XFILLER_0_12_233 VPWR VGND VPWR VGND sky130_ef_sc_hd__decap_12
XFILLER_0_40_3 VPWR VGND VPWR VGND sky130_ef_sc_hd__decap_12
XFILLER_0_12_277 VPWR VGND VPWR VGND sky130_ef_sc_hd__decap_12
XFILLER_0_7_293 VGND VGND VPWR VPWR sky130_fd_sc_hd__decap_6
X_723_ _152_ net7 VGND VGND VPWR VPWR _335_ sky130_fd_sc_hd__nand2_1
X_654_ _257_ _268_ VGND VGND VPWR VPWR _269_ sky130_fd_sc_hd__or2_1
XFILLER_0_38_141 VGND VGND VPWR VPWR sky130_fd_sc_hd__decap_3
X_585_ _199_ _200_ _194_ _195_ VGND VGND VPWR VPWR _202_ sky130_fd_sc_hd__a211o_1
XFILLER_0_30_68 VGND VGND VPWR VPWR sky130_fd_sc_hd__fill_2
XFILLER_0_39_66 VPWR VGND VPWR VGND sky130_ef_sc_hd__decap_12
XFILLER_0_39_55 VGND VGND VPWR VPWR sky130_fd_sc_hd__fill_1
XTAP_269 VGND VPWR sky130_fd_sc_hd__tapvpwrvgnd_1
XTAP_258 VGND VPWR sky130_fd_sc_hd__tapvpwrvgnd_1
XTAP_203 VGND VPWR sky130_fd_sc_hd__tapvpwrvgnd_1
XTAP_214 VGND VPWR sky130_fd_sc_hd__tapvpwrvgnd_1
XTAP_225 VGND VPWR sky130_fd_sc_hd__tapvpwrvgnd_1
XTAP_236 VGND VPWR sky130_fd_sc_hd__tapvpwrvgnd_1
XTAP_247 VGND VPWR sky130_fd_sc_hd__tapvpwrvgnd_1
XFILLER_0_44_133 VGND VGND VPWR VPWR sky130_fd_sc_hd__decap_6
XFILLER_0_44_177 VPWR VGND VPWR VGND sky130_ef_sc_hd__decap_12
XFILLER_0_35_133 VGND VGND VPWR VPWR sky130_fd_sc_hd__decap_3
X_706_ _316_ _318_ VGND VGND VPWR VPWR _319_ sky130_fd_sc_hd__xor2_1
X_637_ _087_ _147_ _219_ _224_ VGND VGND VPWR VPWR _252_ sky130_fd_sc_hd__a31oi_2
XFILLER_0_25_46 VGND VGND VPWR VPWR sky130_fd_sc_hd__decap_8
XFILLER_0_25_57 VPWR VGND VPWR VGND sky130_ef_sc_hd__decap_12
X_499_ net11 net1 net5 net15 VGND VGND VPWR VPWR _118_ sky130_fd_sc_hd__and4_1
X_568_ _079_ _181_ _184_ VGND VGND VPWR VPWR _185_ sky130_fd_sc_hd__and3_1
XFILLER_0_41_169 VPWR VGND VPWR VGND sky130_ef_sc_hd__decap_12
XFILLER_0_41_125 VPWR VGND VPWR VGND sky130_ef_sc_hd__decap_12
XFILLER_0_32_114 VGND VGND VPWR VPWR sky130_fd_sc_hd__decap_3
XFILLER_0_17_111 VGND VGND VPWR VPWR sky130_fd_sc_hd__fill_1
XFILLER_0_17_188 VPWR VGND VPWR VGND sky130_ef_sc_hd__decap_12
XFILLER_0_11_15 VPWR VGND VPWR VGND sky130_ef_sc_hd__decap_12
XFILLER_0_23_125 VGND VGND VPWR VPWR sky130_fd_sc_hd__decap_4
XFILLER_0_23_169 VGND VGND VPWR VPWR sky130_fd_sc_hd__fill_1
Xinput8 activation[7] VGND VGND VPWR VPWR net8 sky130_fd_sc_hd__buf_1
XTAP_97 VGND VPWR sky130_fd_sc_hd__tapvpwrvgnd_1
XFILLER_0_46_217 VGND VGND VPWR VPWR sky130_fd_sc_hd__decap_6
XFILLER_0_9_174 VPWR VGND VPWR VGND sky130_ef_sc_hd__decap_12
XFILLER_0_45_261 VPWR VGND VPWR VGND sky130_ef_sc_hd__decap_12
XPHY_92 VGND VGND VPWR VPWR sky130_fd_sc_hd__decap_3
XPHY_81 VGND VGND VPWR VPWR sky130_fd_sc_hd__decap_3
XPHY_70 VGND VGND VPWR VPWR sky130_fd_sc_hd__decap_3
XFILLER_0_42_297 VGND VGND VPWR VPWR sky130_fd_sc_hd__fill_2
XFILLER_0_42_253 VPWR VGND VPWR VGND sky130_ef_sc_hd__decap_12
XFILLER_0_6_177 VPWR VGND VPWR VGND sky130_ef_sc_hd__decap_12
XFILLER_0_6_133 VGND VGND VPWR VPWR sky130_fd_sc_hd__decap_6
XFILLER_0_27_261 VGND VGND VPWR VPWR sky130_fd_sc_hd__decap_3
XFILLER_0_33_220 VGND VGND VPWR VPWR sky130_fd_sc_hd__decap_4
XFILLER_0_33_264 VPWR VGND VPWR VGND sky130_ef_sc_hd__decap_12
X_885_ _443_ VGND VGND VPWR VPWR _061_ sky130_fd_sc_hd__inv_2
XFILLER_0_17_47 VGND VGND VPWR VPWR sky130_fd_sc_hd__decap_8
XFILLER_0_33_57 VPWR VGND VPWR VGND sky130_ef_sc_hd__decap_12
Xinput11 weight[1] VGND VGND VPWR VPWR net11 sky130_fd_sc_hd__buf_6
XFILLER_0_3_169 VPWR VGND VPWR VGND sky130_ef_sc_hd__decap_12
XFILLER_0_3_125 VPWR VGND VPWR VGND sky130_ef_sc_hd__decap_12
XFILLER_0_30_223 VPWR VGND VPWR VGND sky130_ef_sc_hd__decap_12
X_670_ _077_ net7 VGND VGND VPWR VPWR _284_ sky130_fd_sc_hd__nand2_1
XFILLER_0_21_223 VGND VGND VPWR VPWR sky130_fd_sc_hd__fill_1
X_868_ _442_ VGND VGND VPWR VPWR _045_ sky130_fd_sc_hd__inv_2
X_799_ _399_ _400_ VGND VGND VPWR VPWR _401_ sky130_fd_sc_hd__and2b_1
XFILLER_0_12_245 VGND VGND VPWR VPWR sky130_fd_sc_hd__decap_6
XFILLER_0_33_3 VPWR VGND VPWR VGND sky130_ef_sc_hd__decap_12
XFILLER_0_12_289 VGND VGND VPWR VPWR sky130_fd_sc_hd__decap_8
XFILLER_0_7_261 VPWR VGND VPWR VGND sky130_ef_sc_hd__decap_12
X_653_ _266_ _267_ VGND VGND VPWR VPWR _268_ sky130_fd_sc_hd__xnor2_1
X_722_ _116_ _181_ VGND VGND VPWR VPWR _334_ sky130_fd_sc_hd__nand2_1
XFILLER_0_38_197 VPWR VGND VPWR VGND sky130_ef_sc_hd__decap_12
XFILLER_0_38_164 VPWR VGND VPWR VGND sky130_ef_sc_hd__decap_12
X_584_ _194_ _195_ _199_ _200_ VGND VGND VPWR VPWR _201_ sky130_fd_sc_hd__o211a_1
XFILLER_0_14_15 VPWR VGND VPWR VGND sky130_ef_sc_hd__decap_12
XFILLER_0_39_78 VGND VGND VPWR VPWR sky130_fd_sc_hd__decap_6
XTAP_259 VGND VPWR sky130_fd_sc_hd__tapvpwrvgnd_1
XTAP_204 VGND VPWR sky130_fd_sc_hd__tapvpwrvgnd_1
XTAP_215 VGND VPWR sky130_fd_sc_hd__tapvpwrvgnd_1
XTAP_226 VGND VPWR sky130_fd_sc_hd__tapvpwrvgnd_1
XTAP_237 VGND VPWR sky130_fd_sc_hd__tapvpwrvgnd_1
XTAP_248 VGND VPWR sky130_fd_sc_hd__tapvpwrvgnd_1
XFILLER_0_44_189 VGND VGND VPWR VPWR sky130_fd_sc_hd__decap_6
XFILLER_0_4_253 VPWR VGND VPWR VGND sky130_ef_sc_hd__decap_12
XFILLER_0_35_101 VGND VGND VPWR VPWR sky130_fd_sc_hd__fill_1
XFILLER_0_35_156 VPWR VGND VPWR VGND sky130_ef_sc_hd__decap_12
X_636_ net43 net35 VGND VGND VPWR VPWR _030_ sky130_fd_sc_hd__xor2_1
X_705_ _317_ net7 _290_ VGND VGND VPWR VPWR _318_ sky130_fd_sc_hd__mux2_1
X_567_ _182_ _183_ VGND VGND VPWR VPWR _184_ sky130_fd_sc_hd__xnor2_1
XFILLER_0_25_69 VPWR VGND VPWR VGND sky130_ef_sc_hd__decap_12
XFILLER_0_41_57 VPWR VGND VPWR VGND sky130_ef_sc_hd__decap_12
X_498_ _084_ net5 _116_ net1 VGND VGND VPWR VPWR _117_ sky130_fd_sc_hd__a22oi_1
XFILLER_0_41_137 VPWR VGND VPWR VGND sky130_ef_sc_hd__decap_12
XFILLER_0_1_223 VGND VGND VPWR VPWR sky130_fd_sc_hd__fill_1
XFILLER_0_5_57 VPWR VGND VPWR VGND sky130_ef_sc_hd__decap_12
XFILLER_0_32_137 VGND VGND VPWR VPWR sky130_fd_sc_hd__decap_3
XFILLER_0_11_27 VPWR VGND VPWR VGND sky130_ef_sc_hd__decap_12
XFILLER_0_31_192 VPWR VGND VPWR VGND sky130_ef_sc_hd__decap_12
Xinput9 net46 VGND VGND VPWR VPWR net9 sky130_fd_sc_hd__buf_2
X_619_ _232_ _233_ _234_ VGND VGND VPWR VPWR _235_ sky130_fd_sc_hd__nand3_1
XTAP_98 VGND VPWR sky130_fd_sc_hd__tapvpwrvgnd_1
XFILLER_0_39_281 VPWR VGND VPWR VGND sky130_ef_sc_hd__decap_12
XFILLER_0_14_104 VGND VGND VPWR VPWR sky130_fd_sc_hd__decap_8
XFILLER_0_14_126 VPWR VGND VPWR VGND sky130_ef_sc_hd__decap_12
XFILLER_0_22_170 VPWR VGND VPWR VGND sky130_ef_sc_hd__decap_12
XFILLER_0_45_273 VGND VGND VPWR VPWR sky130_fd_sc_hd__decap_6
XFILLER_0_9_164 VGND VGND VPWR VPWR sky130_fd_sc_hd__decap_4
XFILLER_0_9_186 VPWR VGND VPWR VGND sky130_ef_sc_hd__decap_12
XPHY_82 VGND VGND VPWR VPWR sky130_fd_sc_hd__decap_3
XPHY_71 VGND VGND VPWR VPWR sky130_fd_sc_hd__decap_3
XPHY_60 VGND VGND VPWR VPWR sky130_fd_sc_hd__decap_3
XPHY_93 VGND VGND VPWR VPWR sky130_fd_sc_hd__decap_3
XFILLER_0_36_251 VGND VGND VPWR VPWR sky130_fd_sc_hd__fill_1
XFILLER_0_42_265 VPWR VGND VPWR VGND sky130_ef_sc_hd__decap_12
XFILLER_0_42_221 VPWR VGND VPWR VGND sky130_ef_sc_hd__decap_12
XFILLER_0_6_189 VGND VGND VPWR VPWR sky130_fd_sc_hd__decap_6
XFILLER_0_12_81 VGND VGND VPWR VPWR sky130_fd_sc_hd__decap_3
XFILLER_0_12_92 VPWR VGND VPWR VGND sky130_ef_sc_hd__decap_12
XFILLER_0_18_251 VGND VGND VPWR VPWR sky130_fd_sc_hd__fill_1
XFILLER_0_33_276 VGND VGND VPWR VPWR sky130_fd_sc_hd__decap_4
X_884_ _443_ VGND VGND VPWR VPWR _060_ sky130_fd_sc_hd__inv_2
XFILLER_0_17_15 VPWR VGND VPWR VGND sky130_ef_sc_hd__decap_12
XFILLER_0_33_69 VGND VGND VPWR VPWR sky130_fd_sc_hd__fill_1
Xinput12 weight[2] VGND VGND VPWR VPWR net12 sky130_fd_sc_hd__clkbuf_2
XFILLER_0_3_137 VPWR VGND VPWR VGND sky130_ef_sc_hd__decap_12
XFILLER_0_24_210 VPWR VGND VPWR VGND sky130_ef_sc_hd__decap_12
XFILLER_0_30_235 VGND VGND VPWR VPWR sky130_fd_sc_hd__fill_1
XFILLER_0_21_279 VGND VGND VPWR VPWR sky130_fd_sc_hd__fill_1
X_867_ _442_ VGND VGND VPWR VPWR _044_ sky130_fd_sc_hd__inv_2
X_798_ mult_reg\[6\] net30 VGND VGND VPWR VPWR _400_ sky130_fd_sc_hd__nand2_1
XFILLER_0_26_3 VPWR VGND VPWR VGND sky130_ef_sc_hd__decap_12
XFILLER_0_7_273 VGND VGND VPWR VPWR sky130_fd_sc_hd__decap_6
X_652_ _228_ _236_ _235_ VGND VGND VPWR VPWR _267_ sky130_fd_sc_hd__a21boi_1
X_583_ _197_ _198_ _196_ VGND VGND VPWR VPWR _200_ sky130_fd_sc_hd__a21o_1
XFILLER_0_14_27 VGND VGND VPWR VPWR sky130_fd_sc_hd__fill_1
X_721_ _311_ _312_ _314_ VGND VGND VPWR VPWR _333_ sky130_fd_sc_hd__and3_1
XTAP_205 VGND VPWR sky130_fd_sc_hd__tapvpwrvgnd_1
XTAP_216 VGND VPWR sky130_fd_sc_hd__tapvpwrvgnd_1
XTAP_227 VGND VPWR sky130_fd_sc_hd__tapvpwrvgnd_1
X_919_ clknet_2_0__leaf_clk _026_ _063_ VGND VGND VPWR VPWR mult_reg\[15\] sky130_fd_sc_hd__dfrtp_1
XTAP_238 VGND VPWR sky130_fd_sc_hd__tapvpwrvgnd_1
XTAP_249 VGND VPWR sky130_fd_sc_hd__tapvpwrvgnd_1
XFILLER_0_29_110 VGND VGND VPWR VPWR sky130_fd_sc_hd__fill_2
XFILLER_0_4_265 VPWR VGND VPWR VGND sky130_ef_sc_hd__decap_12
XFILLER_0_4_221 VPWR VGND VPWR VGND sky130_ef_sc_hd__decap_12
XFILLER_0_20_70 VPWR VGND VPWR VGND sky130_ef_sc_hd__decap_12
XFILLER_0_35_113 VPWR VGND VPWR VGND sky130_ef_sc_hd__decap_12
X_704_ _116_ net7 VGND VGND VPWR VPWR _317_ sky130_fd_sc_hd__nand2_1
X_566_ _084_ net7 VGND VGND VPWR VPWR _183_ sky130_fd_sc_hd__nand2_1
X_635_ _171_ _212_ _211_ VGND VGND VPWR VPWR _251_ sky130_fd_sc_hd__a21o_1
XFILLER_0_41_149 VPWR VGND VPWR VGND sky130_ef_sc_hd__decap_12
XFILLER_0_41_105 VGND VGND VPWR VPWR sky130_fd_sc_hd__decap_6
XFILLER_0_41_69 VPWR VGND VPWR VGND sky130_ef_sc_hd__decap_12
X_497_ net15 VGND VGND VPWR VPWR _116_ sky130_fd_sc_hd__buf_6
XFILLER_0_26_124 VGND VGND VPWR VPWR sky130_fd_sc_hd__decap_8
XFILLER_0_5_69 VPWR VGND VPWR VGND sky130_ef_sc_hd__decap_12
XFILLER_0_1_279 VGND VGND VPWR VPWR sky130_fd_sc_hd__fill_1
XFILLER_0_15_70 VGND VGND VPWR VPWR sky130_fd_sc_hd__decap_3
XFILLER_0_11_39 VGND VGND VPWR VPWR sky130_fd_sc_hd__decap_8
XFILLER_0_23_138 VPWR VGND VPWR VGND sky130_ef_sc_hd__decap_12
XFILLER_0_39_293 VGND VGND VPWR VPWR sky130_fd_sc_hd__decap_6
XTAP_99 VGND VPWR sky130_fd_sc_hd__tapvpwrvgnd_1
X_618_ _196_ _197_ _198_ VGND VGND VPWR VPWR _234_ sky130_fd_sc_hd__a21bo_1
X_549_ _164_ _165_ _166_ VGND VGND VPWR VPWR _167_ sky130_fd_sc_hd__nand3_1
XFILLER_0_14_138 VGND VGND VPWR VPWR sky130_fd_sc_hd__fill_2
XFILLER_0_22_182 VPWR VGND VPWR VGND sky130_ef_sc_hd__decap_12
XFILLER_0_9_110 VGND VGND VPWR VPWR sky130_fd_sc_hd__fill_2
XFILLER_0_9_198 VPWR VGND VPWR VGND sky130_ef_sc_hd__decap_12
XPHY_83 VGND VGND VPWR VPWR sky130_fd_sc_hd__decap_3
XPHY_72 VGND VGND VPWR VPWR sky130_fd_sc_hd__decap_3
XFILLER_0_22_27 VGND VGND VPWR VPWR sky130_fd_sc_hd__fill_1
XPHY_50 VGND VGND VPWR VPWR sky130_fd_sc_hd__decap_3
XPHY_61 VGND VGND VPWR VPWR sky130_fd_sc_hd__decap_3
XFILLER_0_42_277 VPWR VGND VPWR VGND sky130_ef_sc_hd__decap_12
XFILLER_0_42_233 VPWR VGND VPWR VGND sky130_ef_sc_hd__decap_12
XFILLER_0_10_141 VPWR VGND VPWR VGND sky130_ef_sc_hd__decap_12
XFILLER_0_10_163 VGND VGND VPWR VPWR sky130_fd_sc_hd__fill_1
X_883_ _443_ VGND VGND VPWR VPWR _059_ sky130_fd_sc_hd__inv_2
XFILLER_0_33_15 VPWR VGND VPWR VGND sky130_ef_sc_hd__decap_12
XFILLER_0_17_27 VGND VGND VPWR VPWR sky130_fd_sc_hd__fill_2
Xinput13 weight[3] VGND VGND VPWR VPWR net13 sky130_fd_sc_hd__clkbuf_2
XFILLER_0_3_149 VPWR VGND VPWR VGND sky130_ef_sc_hd__decap_12
XFILLER_0_3_105 VGND VGND VPWR VPWR sky130_fd_sc_hd__decap_6
XFILLER_0_42_9 VPWR VGND VPWR VGND sky130_ef_sc_hd__decap_12
XFILLER_0_23_81 VGND VGND VPWR VPWR sky130_fd_sc_hd__decap_8
Xclkbuf_2_2__f_clk clknet_0_clk VGND VGND VPWR VPWR clknet_2_2__leaf_clk sky130_fd_sc_hd__clkbuf_16
XFILLER_0_21_203 VGND VGND VPWR VPWR sky130_fd_sc_hd__decap_4
XFILLER_0_21_225 VGND VGND VPWR VPWR sky130_fd_sc_hd__decap_8
X_866_ _442_ VGND VGND VPWR VPWR _043_ sky130_fd_sc_hd__inv_2
X_797_ mult_reg\[6\] net30 VGND VGND VPWR VPWR _399_ sky130_fd_sc_hd__nor2_1
XFILLER_0_19_3 VPWR VGND VPWR VGND sky130_ef_sc_hd__decap_12
XFILLER_0_34_91 VPWR VGND VPWR VGND sky130_ef_sc_hd__decap_12
X_720_ _322_ _323_ VGND VGND VPWR VPWR _332_ sky130_fd_sc_hd__nor2_1
X_651_ _260_ _265_ VGND VGND VPWR VPWR _266_ sky130_fd_sc_hd__xnor2_1
X_582_ _196_ _197_ _198_ VGND VGND VPWR VPWR _199_ sky130_fd_sc_hd__nand3_1
XTAP_206 VGND VPWR sky130_fd_sc_hd__tapvpwrvgnd_1
XTAP_217 VGND VPWR sky130_fd_sc_hd__tapvpwrvgnd_1
XTAP_228 VGND VPWR sky130_fd_sc_hd__tapvpwrvgnd_1
XTAP_239 VGND VPWR sky130_fd_sc_hd__tapvpwrvgnd_1
X_918_ clknet_2_0__leaf_clk _025_ _062_ VGND VGND VPWR VPWR mult_reg\[14\] sky130_fd_sc_hd__dfrtp_1
X_849_ _109_ _110_ VGND VGND VPWR VPWR _018_ sky130_fd_sc_hd__xnor2_1
XFILLER_0_4_277 VPWR VGND VPWR VGND sky130_ef_sc_hd__decap_12
XFILLER_0_4_233 VPWR VGND VPWR VGND sky130_ef_sc_hd__decap_12
XFILLER_0_20_82 VGND VGND VPWR VPWR sky130_fd_sc_hd__fill_2
XFILLER_0_35_169 VPWR VGND VPWR VGND sky130_ef_sc_hd__decap_12
XFILLER_0_35_125 VGND VGND VPWR VPWR sky130_fd_sc_hd__decap_8
XFILLER_0_8_3 VPWR VGND VPWR VGND sky130_ef_sc_hd__decap_12
X_703_ _077_ _181_ VGND VGND VPWR VPWR _316_ sky130_fd_sc_hd__nand2_1
X_634_ _248_ _249_ VGND VGND VPWR VPWR _250_ sky130_fd_sc_hd__nor2_1
XFILLER_0_41_15 VPWR VGND VPWR VGND sky130_ef_sc_hd__decap_12
X_565_ _084_ _145_ _155_ _154_ VGND VGND VPWR VPWR _182_ sky130_fd_sc_hd__a31o_1
X_496_ _115_ VGND VGND VPWR VPWR _020_ sky130_fd_sc_hd__clkbuf_1
XFILLER_0_34_180 VPWR VGND VPWR VGND sky130_ef_sc_hd__decap_12
XFILLER_0_1_225 VPWR VGND VPWR VGND sky130_ef_sc_hd__decap_12
XFILLER_0_5_15 VPWR VGND VPWR VGND sky130_ef_sc_hd__decap_12
XFILLER_0_17_136 VGND VGND VPWR VPWR sky130_fd_sc_hd__fill_1
XFILLER_0_17_169 VGND VGND VPWR VPWR sky130_fd_sc_hd__decap_3
XFILLER_0_32_106 VGND VGND VPWR VPWR sky130_fd_sc_hd__decap_8
XFILLER_0_31_81 VGND VGND VPWR VPWR sky130_fd_sc_hd__decap_6
XFILLER_0_31_161 VGND VGND VPWR VPWR sky130_fd_sc_hd__decap_6
XFILLER_0_36_59 VPWR VGND VPWR VGND sky130_ef_sc_hd__decap_12
XFILLER_0_36_37 VGND VGND VPWR VPWR sky130_fd_sc_hd__fill_1
X_617_ _230_ _231_ _229_ VGND VGND VPWR VPWR _233_ sky130_fd_sc_hd__a21o_1
XFILLER_0_39_261 VPWR VGND VPWR VGND sky130_ef_sc_hd__decap_12
X_479_ _075_ _066_ _074_ VGND VGND VPWR VPWR _099_ sky130_fd_sc_hd__or3_4
X_548_ _121_ _129_ _128_ VGND VGND VPWR VPWR _166_ sky130_fd_sc_hd__a21bo_1
XFILLER_0_22_194 VGND VGND VPWR VPWR sky130_fd_sc_hd__fill_2
XFILLER_0_9_122 VGND VGND VPWR VPWR sky130_fd_sc_hd__fill_2
XFILLER_0_9_144 VPWR VGND VPWR VGND sky130_ef_sc_hd__decap_12
XFILLER_0_13_183 VGND VGND VPWR VPWR sky130_fd_sc_hd__fill_1
XPHY_84 VGND VGND VPWR VPWR sky130_fd_sc_hd__decap_3
XPHY_73 VGND VGND VPWR VPWR sky130_fd_sc_hd__decap_3
XFILLER_0_36_253 VPWR VGND VPWR VGND sky130_ef_sc_hd__decap_12
XPHY_40 VGND VGND VPWR VPWR sky130_fd_sc_hd__decap_3
XPHY_51 VGND VGND VPWR VPWR sky130_fd_sc_hd__decap_3
XPHY_62 VGND VGND VPWR VPWR sky130_fd_sc_hd__decap_3
XFILLER_0_36_297 VGND VGND VPWR VPWR sky130_fd_sc_hd__fill_2
XFILLER_0_2_27 VGND VGND VPWR VPWR sky130_fd_sc_hd__fill_1
XFILLER_0_42_245 VGND VGND VPWR VPWR sky130_fd_sc_hd__decap_6
XFILLER_0_42_289 VGND VGND VPWR VPWR sky130_fd_sc_hd__decap_8
XFILLER_0_10_197 VGND VGND VPWR VPWR sky130_fd_sc_hd__decap_6
XFILLER_0_18_231 VGND VGND VPWR VPWR sky130_fd_sc_hd__decap_4
XFILLER_0_18_253 VPWR VGND VPWR VGND sky130_ef_sc_hd__decap_12
XFILLER_0_33_245 VGND VGND VPWR VPWR sky130_fd_sc_hd__fill_1
XFILLER_0_33_212 VGND VGND VPWR VPWR sky130_fd_sc_hd__decap_4
XFILLER_0_18_297 VGND VGND VPWR VPWR sky130_fd_sc_hd__fill_2
X_882_ _443_ VGND VGND VPWR VPWR _058_ sky130_fd_sc_hd__inv_2
XFILLER_0_33_27 VPWR VGND VPWR VGND sky130_ef_sc_hd__decap_12
Xinput14 weight[4] VGND VGND VPWR VPWR net14 sky130_fd_sc_hd__clkbuf_2
XFILLER_0_15_223 VGND VGND VPWR VPWR sky130_fd_sc_hd__fill_1
XFILLER_0_3_81 VPWR VGND VPWR VGND sky130_ef_sc_hd__decap_12
XFILLER_0_21_215 VGND VGND VPWR VPWR sky130_fd_sc_hd__decap_8
XFILLER_0_44_15 VPWR VGND VPWR VGND sky130_ef_sc_hd__decap_12
X_865_ _442_ VGND VGND VPWR VPWR _042_ sky130_fd_sc_hd__inv_2
X_796_ _394_ _395_ _396_ VGND VGND VPWR VPWR _398_ sky130_fd_sc_hd__o21a_1
XFILLER_0_8_209 VPWR VGND VPWR VGND sky130_ef_sc_hd__decap_12
XFILLER_0_8_15 VPWR VGND VPWR VGND sky130_ef_sc_hd__decap_12
X_650_ _263_ _264_ VGND VGND VPWR VPWR _265_ sky130_fd_sc_hd__xor2_1
XFILLER_0_11_281 VPWR VGND VPWR VGND sky130_ef_sc_hd__decap_12
X_581_ _085_ net3 net14 net15 VGND VGND VPWR VPWR _198_ sky130_fd_sc_hd__nand4_1
XFILLER_0_14_29 VGND VGND VPWR VPWR sky130_fd_sc_hd__decap_6
XFILLER_0_39_15 VPWR VGND VPWR VGND sky130_ef_sc_hd__decap_12
XTAP_207 VGND VPWR sky130_fd_sc_hd__tapvpwrvgnd_1
XTAP_218 VGND VPWR sky130_fd_sc_hd__tapvpwrvgnd_1
XTAP_229 VGND VPWR sky130_fd_sc_hd__tapvpwrvgnd_1
X_917_ clknet_2_0__leaf_clk _024_ _061_ VGND VGND VPWR VPWR mult_reg\[13\] sky130_fd_sc_hd__dfrtp_1
X_848_ _110_ _438_ VGND VGND VPWR VPWR _017_ sky130_fd_sc_hd__nor2_1
X_779_ _383_ _384_ VGND VGND VPWR VPWR _385_ sky130_fd_sc_hd__and2b_1
XFILLER_0_29_167 VGND VGND VPWR VPWR sky130_fd_sc_hd__fill_1
XFILLER_0_29_178 VGND VGND VPWR VPWR sky130_fd_sc_hd__fill_1
XFILLER_0_4_289 VGND VGND VPWR VPWR sky130_fd_sc_hd__decap_6
XFILLER_0_4_245 VGND VGND VPWR VPWR sky130_fd_sc_hd__decap_6
XFILLER_0_31_3 VGND VGND VPWR VPWR sky130_fd_sc_hd__decap_6
XFILLER_0_43_181 VPWR VGND VPWR VGND sky130_ef_sc_hd__decap_12
X_702_ _313_ _314_ VGND VGND VPWR VPWR _315_ sky130_fd_sc_hd__xnor2_1
X_633_ _246_ _247_ _214_ _215_ VGND VGND VPWR VPWR _249_ sky130_fd_sc_hd__a211oi_1
XFILLER_0_41_27 VPWR VGND VPWR VGND sky130_ef_sc_hd__decap_12
X_564_ net8 VGND VGND VPWR VPWR _181_ sky130_fd_sc_hd__buf_2
X_495_ net39 _114_ VGND VGND VPWR VPWR _115_ sky130_fd_sc_hd__and2_1
XFILLER_0_34_192 VGND VGND VPWR VPWR sky130_fd_sc_hd__fill_1
XFILLER_0_1_237 VPWR VGND VPWR VGND sky130_ef_sc_hd__decap_12
XFILLER_0_5_27 VPWR VGND VPWR VGND sky130_ef_sc_hd__decap_12
XFILLER_0_32_129 VGND VGND VPWR VPWR sky130_fd_sc_hd__decap_8
XFILLER_0_40_195 VGND VGND VPWR VPWR sky130_fd_sc_hd__fill_1
XFILLER_0_25_181 VPWR VGND VPWR VGND sky130_ef_sc_hd__decap_12
XFILLER_0_23_129 VGND VGND VPWR VPWR sky130_fd_sc_hd__fill_1
XFILLER_0_36_27 VGND VGND VPWR VPWR sky130_fd_sc_hd__fill_1
X_616_ _229_ _230_ _231_ VGND VGND VPWR VPWR _232_ sky130_fd_sc_hd__nand3_1
X_547_ _162_ _163_ _156_ VGND VGND VPWR VPWR _165_ sky130_fd_sc_hd__a21o_1
XFILLER_0_39_273 VGND VGND VPWR VPWR sky130_fd_sc_hd__decap_6
X_478_ _095_ _096_ _076_ VGND VGND VPWR VPWR _098_ sky130_fd_sc_hd__a21o_1
XFILLER_0_26_82 VGND VGND VPWR VPWR sky130_fd_sc_hd__fill_2
XPHY_30 VGND VGND VPWR VPWR sky130_fd_sc_hd__decap_3
XPHY_85 VGND VGND VPWR VPWR sky130_fd_sc_hd__decap_3
XPHY_74 VGND VGND VPWR VPWR sky130_fd_sc_hd__decap_3
XFILLER_0_36_265 VPWR VGND VPWR VGND sky130_ef_sc_hd__decap_12
XFILLER_0_36_221 VPWR VGND VPWR VGND sky130_ef_sc_hd__decap_12
XPHY_63 VGND VGND VPWR VPWR sky130_fd_sc_hd__decap_3
XPHY_41 VGND VGND VPWR VPWR sky130_fd_sc_hd__decap_3
XFILLER_0_22_29 VPWR VGND VPWR VGND sky130_ef_sc_hd__decap_12
XPHY_52 VGND VGND VPWR VPWR sky130_fd_sc_hd__decap_3
XFILLER_0_18_265 VPWR VGND VPWR VGND sky130_ef_sc_hd__decap_12
XFILLER_0_5_181 VPWR VGND VPWR VGND sky130_ef_sc_hd__decap_12
X_881_ _443_ VGND VGND VPWR VPWR _057_ sky130_fd_sc_hd__inv_2
XFILLER_0_33_39 VPWR VGND VPWR VGND sky130_ef_sc_hd__decap_12
Xinput15 weight[5] VGND VGND VPWR VPWR net15 sky130_fd_sc_hd__buf_2
XFILLER_0_24_246 VGND VGND VPWR VPWR sky130_fd_sc_hd__fill_2
XFILLER_0_32_290 VGND VGND VPWR VPWR sky130_fd_sc_hd__decap_8
XFILLER_0_28_9 VGND VGND VPWR VPWR sky130_fd_sc_hd__fill_1
XFILLER_0_30_216 VGND VGND VPWR VPWR sky130_fd_sc_hd__fill_2
XFILLER_0_2_195 VGND VGND VPWR VPWR sky130_fd_sc_hd__fill_1
XFILLER_0_3_93 VPWR VGND VPWR VGND sky130_ef_sc_hd__decap_12
XFILLER_0_44_27 VGND VGND VPWR VPWR sky130_fd_sc_hd__fill_1
X_795_ _394_ _397_ VGND VGND VPWR VPWR _011_ sky130_fd_sc_hd__xnor2_1
X_864_ net9 VGND VGND VPWR VPWR _442_ sky130_fd_sc_hd__clkbuf_8
XFILLER_0_8_27 VGND VGND VPWR VPWR sky130_fd_sc_hd__fill_1
XFILLER_0_18_83 VGND VGND VPWR VPWR sky130_fd_sc_hd__fill_1
XFILLER_0_11_293 VGND VGND VPWR VPWR sky130_fd_sc_hd__decap_6
X_580_ net4 net14 net15 net3 VGND VGND VPWR VPWR _197_ sky130_fd_sc_hd__a22o_1
XFILLER_0_38_113 VGND VGND VPWR VPWR sky130_fd_sc_hd__decap_3
XFILLER_0_38_102 VGND VGND VPWR VPWR sky130_fd_sc_hd__decap_4
XFILLER_0_39_27 VPWR VGND VPWR VGND sky130_ef_sc_hd__decap_12
X_916_ clknet_2_0__leaf_clk _023_ _060_ VGND VGND VPWR VPWR mult_reg\[12\] sky130_fd_sc_hd__dfrtp_1
XTAP_208 VGND VPWR sky130_fd_sc_hd__tapvpwrvgnd_1
XTAP_219 VGND VPWR sky130_fd_sc_hd__tapvpwrvgnd_1
X_847_ _072_ _079_ _065_ _084_ VGND VGND VPWR VPWR _438_ sky130_fd_sc_hd__a22oi_1
XFILLER_0_29_102 VGND VGND VPWR VPWR sky130_fd_sc_hd__decap_8
X_778_ mult_reg\[2\] net26 VGND VGND VPWR VPWR _384_ sky130_fd_sc_hd__nand2_1
XFILLER_0_29_113 VPWR VGND VPWR VGND sky130_ef_sc_hd__decap_12
XFILLER_0_29_146 VPWR VGND VPWR VGND sky130_ef_sc_hd__decap_12
XFILLER_0_45_81 VPWR VGND VPWR VGND sky130_ef_sc_hd__decap_12
XFILLER_0_0_83 VGND VGND VPWR VPWR sky130_fd_sc_hd__fill_1
XFILLER_0_43_193 VPWR VGND VPWR VGND sky130_ef_sc_hd__decap_12
XFILLER_0_9_81 VGND VGND VPWR VPWR sky130_fd_sc_hd__decap_4
X_701_ _289_ _291_ _294_ _262_ VGND VGND VPWR VPWR _314_ sky130_fd_sc_hd__a31o_1
X_563_ _148_ VGND VGND VPWR VPWR _180_ sky130_fd_sc_hd__inv_2
X_632_ _214_ _215_ _246_ _247_ VGND VGND VPWR VPWR _248_ sky130_fd_sc_hd__o211a_1
XFILLER_0_41_39 VPWR VGND VPWR VGND sky130_ef_sc_hd__decap_12
XFILLER_0_26_105 VGND VGND VPWR VPWR sky130_fd_sc_hd__fill_1
X_494_ _105_ _106_ _112_ VGND VGND VPWR VPWR _114_ sky130_fd_sc_hd__o21ai_1
XFILLER_0_1_205 VPWR VGND VPWR VGND sky130_ef_sc_hd__decap_12
XFILLER_0_1_249 VPWR VGND VPWR VGND sky130_ef_sc_hd__decap_12
XFILLER_0_5_39 VPWR VGND VPWR VGND sky130_ef_sc_hd__decap_12
XFILLER_0_17_116 VPWR VGND VPWR VGND sky130_ef_sc_hd__decap_12
XFILLER_0_25_193 VGND VGND VPWR VPWR sky130_fd_sc_hd__decap_3
XFILLER_0_40_141 VPWR VGND VPWR VGND sky130_ef_sc_hd__decap_12
X_615_ _085_ _086_ net15 net16 VGND VGND VPWR VPWR _231_ sky130_fd_sc_hd__nand4_1
X_546_ _156_ _162_ _163_ VGND VGND VPWR VPWR _164_ sky130_fd_sc_hd__nand3_1
X_477_ _076_ _095_ _096_ VGND VGND VPWR VPWR _097_ sky130_fd_sc_hd__nand3_2
XFILLER_0_9_113 VGND VGND VPWR VPWR sky130_fd_sc_hd__decap_3
XPHY_64 VGND VGND VPWR VPWR sky130_fd_sc_hd__decap_3
XPHY_20 VGND VGND VPWR VPWR sky130_fd_sc_hd__decap_3
XPHY_31 VGND VGND VPWR VPWR sky130_fd_sc_hd__decap_3
XPHY_42 VGND VGND VPWR VPWR sky130_fd_sc_hd__decap_3
XPHY_53 VGND VGND VPWR VPWR sky130_fd_sc_hd__decap_3
XPHY_86 VGND VGND VPWR VPWR sky130_fd_sc_hd__decap_3
XPHY_75 VGND VGND VPWR VPWR sky130_fd_sc_hd__decap_3
XFILLER_0_36_277 VPWR VGND VPWR VGND sky130_ef_sc_hd__decap_12
XFILLER_0_36_233 VPWR VGND VPWR VGND sky130_ef_sc_hd__decap_12
XFILLER_0_2_29 VPWR VGND VPWR VGND sky130_ef_sc_hd__decap_12
X_529_ net7 VGND VGND VPWR VPWR _147_ sky130_fd_sc_hd__clkbuf_4
XFILLER_0_27_222 VGND VGND VPWR VPWR sky130_fd_sc_hd__fill_2
XFILLER_0_27_277 VGND VGND VPWR VPWR sky130_fd_sc_hd__decap_3
XFILLER_0_18_277 VPWR VGND VPWR VGND sky130_ef_sc_hd__decap_12
XFILLER_0_5_193 VPWR VGND VPWR VGND sky130_ef_sc_hd__decap_12
X_880_ _443_ VGND VGND VPWR VPWR _056_ sky130_fd_sc_hd__inv_2
Xinput16 weight[6] VGND VGND VPWR VPWR net16 sky130_fd_sc_hd__buf_2
XFILLER_0_2_141 VPWR VGND VPWR VGND sky130_ef_sc_hd__decap_12
XFILLER_0_30_239 VPWR VGND VPWR VGND sky130_ef_sc_hd__decap_12
X_863_ _441_ VGND VGND VPWR VPWR _041_ sky130_fd_sc_hd__inv_2
XFILLER_0_28_29 VPWR VGND VPWR VGND sky130_ef_sc_hd__decap_12
X_794_ _395_ _396_ VGND VGND VPWR VPWR _397_ sky130_fd_sc_hd__and2b_1
XFILLER_0_20_250 VGND VGND VPWR VPWR sky130_fd_sc_hd__fill_2
XFILLER_0_34_83 VGND VGND VPWR VPWR sky130_fd_sc_hd__fill_1
XFILLER_0_11_261 VPWR VGND VPWR VGND sky130_ef_sc_hd__decap_12
XFILLER_0_39_39 VPWR VGND VPWR VGND sky130_ef_sc_hd__decap_12
X_915_ clknet_2_1__leaf_clk _022_ _059_ VGND VGND VPWR VPWR mult_reg\[11\] sky130_fd_sc_hd__dfrtp_1
X_846_ _437_ VGND VGND VPWR VPWR _000_ sky130_fd_sc_hd__clkbuf_1
XTAP_209 VGND VPWR sky130_fd_sc_hd__tapvpwrvgnd_1
XFILLER_0_29_125 VGND VGND VPWR VPWR sky130_fd_sc_hd__decap_4
X_777_ mult_reg\[2\] net26 VGND VGND VPWR VPWR _383_ sky130_fd_sc_hd__nor2_1
XFILLER_0_44_139 VGND VGND VPWR VPWR sky130_fd_sc_hd__fill_1
XFILLER_0_29_158 VGND VGND VPWR VPWR sky130_fd_sc_hd__fill_2
XFILLER_0_20_85 VPWR VGND VPWR VGND sky130_ef_sc_hd__decap_12
XFILLER_0_17_3 VPWR VGND VPWR VGND sky130_ef_sc_hd__decap_12
XFILLER_0_29_83 VPWR VGND VPWR VGND sky130_ef_sc_hd__decap_12
XFILLER_0_45_93 VPWR VGND VPWR VGND sky130_ef_sc_hd__decap_12
XFILLER_0_43_161 VGND VGND VPWR VPWR sky130_fd_sc_hd__decap_6
X_700_ _311_ _312_ VGND VGND VPWR VPWR _313_ sky130_fd_sc_hd__nand2_1
X_493_ _105_ _106_ _112_ VGND VGND VPWR VPWR _113_ sky130_fd_sc_hd__or3_4
X_631_ _244_ _245_ _216_ _185_ VGND VGND VPWR VPWR _247_ sky130_fd_sc_hd__a211o_1
X_562_ _140_ _176_ _174_ _173_ VGND VGND VPWR VPWR _179_ sky130_fd_sc_hd__a211o_1
XFILLER_0_34_150 VGND VGND VPWR VPWR sky130_fd_sc_hd__decap_6
XFILLER_0_1_217 VGND VGND VPWR VPWR sky130_fd_sc_hd__decap_6
X_829_ _423_ _424_ VGND VGND VPWR VPWR _425_ sky130_fd_sc_hd__and2b_1
XFILLER_0_17_128 VGND VGND VPWR VPWR sky130_fd_sc_hd__decap_8
XFILLER_0_40_153 VPWR VGND VPWR VGND sky130_ef_sc_hd__decap_12
XFILLER_0_25_161 VGND VGND VPWR VPWR sky130_fd_sc_hd__fill_1
XFILLER_0_31_95 VGND VGND VPWR VPWR sky130_fd_sc_hd__decap_3
XFILLER_0_40_197 VPWR VGND VPWR VGND sky130_ef_sc_hd__decap_12
XFILLER_0_23_109 VGND VGND VPWR VPWR sky130_fd_sc_hd__decap_3
XFILLER_0_6_3 VPWR VGND VPWR VGND sky130_ef_sc_hd__decap_12
XFILLER_0_31_186 VGND VGND VPWR VPWR sky130_fd_sc_hd__decap_3
XFILLER_0_36_29 VGND VGND VPWR VPWR sky130_fd_sc_hd__decap_8
X_614_ net4 net15 net16 net3 VGND VGND VPWR VPWR _230_ sky130_fd_sc_hd__a22o_1
X_545_ _159_ _160_ _161_ VGND VGND VPWR VPWR _163_ sky130_fd_sc_hd__a21o_1
X_476_ _093_ _094_ _082_ VGND VGND VPWR VPWR _096_ sky130_fd_sc_hd__a21o_1
XFILLER_0_26_62 VGND VGND VPWR VPWR sky130_fd_sc_hd__decap_6
XFILLER_0_45_223 VGND VGND VPWR VPWR sky130_fd_sc_hd__fill_1
XFILLER_0_42_83 VGND VGND VPWR VPWR sky130_fd_sc_hd__fill_1
XFILLER_0_6_83 VGND VGND VPWR VPWR sky130_fd_sc_hd__fill_1
XPHY_87 VGND VGND VPWR VPWR sky130_fd_sc_hd__decap_3
XPHY_76 VGND VGND VPWR VPWR sky130_fd_sc_hd__decap_3
XPHY_65 VGND VGND VPWR VPWR sky130_fd_sc_hd__decap_3
XPHY_10 VGND VGND VPWR VPWR sky130_fd_sc_hd__decap_3
XPHY_21 VGND VGND VPWR VPWR sky130_fd_sc_hd__decap_3
XPHY_32 VGND VGND VPWR VPWR sky130_fd_sc_hd__decap_3
XPHY_43 VGND VGND VPWR VPWR sky130_fd_sc_hd__decap_3
XPHY_54 VGND VGND VPWR VPWR sky130_fd_sc_hd__decap_3
XFILLER_0_36_289 VGND VGND VPWR VPWR sky130_fd_sc_hd__decap_8
XFILLER_0_36_245 VGND VGND VPWR VPWR sky130_fd_sc_hd__decap_6
XFILLER_0_8_180 VPWR VGND VPWR VGND sky130_ef_sc_hd__decap_12
XFILLER_0_6_139 VGND VGND VPWR VPWR sky130_fd_sc_hd__fill_1
X_528_ _079_ _145_ _119_ VGND VGND VPWR VPWR _146_ sky130_fd_sc_hd__and3_1
X_459_ net10 VGND VGND VPWR VPWR _079_ sky130_fd_sc_hd__buf_2
XFILLER_0_10_134 VGND VGND VPWR VPWR sky130_fd_sc_hd__decap_6
XFILLER_0_10_178 VPWR VGND VPWR VGND sky130_ef_sc_hd__decap_12
XFILLER_0_5_161 VGND VGND VPWR VPWR sky130_fd_sc_hd__decap_6
XFILLER_0_18_289 VGND VGND VPWR VPWR sky130_fd_sc_hd__decap_8
XFILLER_0_41_281 VPWR VGND VPWR VGND sky130_ef_sc_hd__decap_12
Xinput17 weight[7] VGND VGND VPWR VPWR net17 sky130_fd_sc_hd__clkbuf_2
XFILLER_0_24_226 VPWR VGND VPWR VGND sky130_ef_sc_hd__decap_12
XFILLER_0_2_197 VPWR VGND VPWR VGND sky130_ef_sc_hd__decap_12
XFILLER_0_2_153 VPWR VGND VPWR VGND sky130_ef_sc_hd__decap_12
XFILLER_0_23_281 VPWR VGND VPWR VGND sky130_ef_sc_hd__decap_12
XFILLER_0_30_207 VGND VGND VPWR VPWR sky130_fd_sc_hd__decap_4
XFILLER_0_3_51 VGND VGND VPWR VPWR sky130_fd_sc_hd__decap_4
X_862_ _441_ VGND VGND VPWR VPWR _040_ sky130_fd_sc_hd__inv_2
XFILLER_0_44_29 VPWR VGND VPWR VGND sky130_ef_sc_hd__decap_12
X_793_ mult_reg\[5\] net29 VGND VGND VPWR VPWR _396_ sky130_fd_sc_hd__nand2_1
XFILLER_0_8_29 VPWR VGND VPWR VGND sky130_ef_sc_hd__decap_12
XFILLER_0_18_85 VGND VGND VPWR VPWR sky130_fd_sc_hd__decap_6
XFILLER_0_34_62 VGND VGND VPWR VPWR sky130_fd_sc_hd__fill_1
XFILLER_0_7_223 VGND VGND VPWR VPWR sky130_fd_sc_hd__fill_1
XFILLER_0_11_273 VGND VGND VPWR VPWR sky130_fd_sc_hd__decap_6
X_914_ clknet_2_1__leaf_clk _021_ _058_ VGND VGND VPWR VPWR mult_reg\[10\] sky130_fd_sc_hd__dfrtp_1
X_776_ mult_reg\[0\] net18 _380_ _381_ VGND VGND VPWR VPWR _382_ sky130_fd_sc_hd__a31oi_4
X_845_ _379_ _436_ VGND VGND VPWR VPWR _437_ sky130_fd_sc_hd__and2_1
XFILLER_0_20_97 VGND VGND VPWR VPWR sky130_fd_sc_hd__fill_2
XFILLER_0_29_73 VGND VGND VPWR VPWR sky130_fd_sc_hd__fill_2
XFILLER_0_29_95 VGND VGND VPWR VPWR sky130_fd_sc_hd__decap_4
XFILLER_0_0_41 VPWR VGND VPWR VGND sky130_ef_sc_hd__decap_12
XFILLER_0_0_85 VPWR VGND VPWR VGND sky130_ef_sc_hd__decap_12
XFILLER_0_28_170 VPWR VGND VPWR VGND sky130_ef_sc_hd__decap_12
XFILLER_0_3_281 VPWR VGND VPWR VGND sky130_ef_sc_hd__decap_12
X_630_ _216_ _185_ _244_ _245_ VGND VGND VPWR VPWR _246_ sky130_fd_sc_hd__o211ai_2
X_492_ _107_ _111_ VGND VGND VPWR VPWR _112_ sky130_fd_sc_hd__nand2_1
X_561_ _097_ _143_ _171_ _172_ VGND VGND VPWR VPWR _178_ sky130_fd_sc_hd__or4_1
X_828_ mult_reg\[12\] net21 VGND VGND VPWR VPWR _424_ sky130_fd_sc_hd__nand2_1
X_759_ _368_ _369_ VGND VGND VPWR VPWR _024_ sky130_fd_sc_hd__xnor2_1
XFILLER_0_40_165 VPWR VGND VPWR VGND sky130_ef_sc_hd__decap_12
XFILLER_0_40_121 VPWR VGND VPWR VGND sky130_ef_sc_hd__decap_12
XFILLER_0_16_195 VGND VGND VPWR VPWR sky130_fd_sc_hd__fill_1
XFILLER_0_36_19 VGND VGND VPWR VPWR sky130_fd_sc_hd__decap_8
X_613_ _072_ net17 VGND VGND VPWR VPWR _229_ sky130_fd_sc_hd__and2_1
X_544_ _159_ _160_ _161_ VGND VGND VPWR VPWR _162_ sky130_fd_sc_hd__nand3_1
X_475_ _082_ _093_ _094_ VGND VGND VPWR VPWR _095_ sky130_fd_sc_hd__nand3_1
XFILLER_0_22_165 VGND VGND VPWR VPWR sky130_fd_sc_hd__fill_2
XFILLER_0_26_74 VGND VGND VPWR VPWR sky130_fd_sc_hd__decap_8
XFILLER_0_26_85 VGND VGND VPWR VPWR sky130_fd_sc_hd__decap_3
XFILLER_0_45_279 VGND VGND VPWR VPWR sky130_fd_sc_hd__fill_1
XFILLER_0_13_110 VGND VGND VPWR VPWR sky130_fd_sc_hd__fill_2
XFILLER_0_13_165 VGND VGND VPWR VPWR sky130_fd_sc_hd__decap_3
XPHY_88 VGND VGND VPWR VPWR sky130_fd_sc_hd__decap_3
XPHY_77 VGND VGND VPWR VPWR sky130_fd_sc_hd__decap_3
XPHY_66 VGND VGND VPWR VPWR sky130_fd_sc_hd__decap_3
XPHY_11 VGND VGND VPWR VPWR sky130_fd_sc_hd__decap_3
XPHY_22 VGND VGND VPWR VPWR sky130_fd_sc_hd__decap_3
XPHY_33 VGND VGND VPWR VPWR sky130_fd_sc_hd__decap_3
XPHY_44 VGND VGND VPWR VPWR sky130_fd_sc_hd__decap_3
XPHY_55 VGND VGND VPWR VPWR sky130_fd_sc_hd__decap_3
XFILLER_0_8_192 VGND VGND VPWR VPWR sky130_fd_sc_hd__decap_4
X_527_ net6 VGND VGND VPWR VPWR _145_ sky130_fd_sc_hd__clkbuf_4
X_458_ net5 VGND VGND VPWR VPWR _078_ sky130_fd_sc_hd__buf_6
XFILLER_0_37_73 VPWR VGND VPWR VGND sky130_ef_sc_hd__decap_12
XFILLER_0_37_51 VGND VGND VPWR VPWR sky130_fd_sc_hd__decap_4
XFILLER_0_33_216 VGND VGND VPWR VPWR sky130_fd_sc_hd__fill_1
XFILLER_0_41_293 VGND VGND VPWR VPWR sky130_fd_sc_hd__decap_6
XTAP_190 VGND VPWR sky130_fd_sc_hd__tapvpwrvgnd_1
XFILLER_0_24_238 VGND VGND VPWR VPWR sky130_fd_sc_hd__decap_8
XFILLER_0_2_121 VPWR VGND VPWR VGND sky130_ef_sc_hd__decap_12
XFILLER_0_23_97 VPWR VGND VPWR VGND sky130_ef_sc_hd__decap_12
XFILLER_0_2_165 VPWR VGND VPWR VGND sky130_ef_sc_hd__decap_12
XFILLER_0_23_293 VGND VGND VPWR VPWR sky130_fd_sc_hd__decap_6
X_792_ mult_reg\[5\] net29 VGND VGND VPWR VPWR _395_ sky130_fd_sc_hd__nor2_1
X_861_ _441_ VGND VGND VPWR VPWR _039_ sky130_fd_sc_hd__inv_2
XFILLER_0_18_75 VGND VGND VPWR VPWR sky130_fd_sc_hd__decap_8
XFILLER_0_34_41 VGND VGND VPWR VPWR sky130_fd_sc_hd__fill_2
XFILLER_0_7_279 VGND VGND VPWR VPWR sky130_fd_sc_hd__fill_1
XFILLER_0_46_193 VGND VGND VPWR VPWR sky130_fd_sc_hd__decap_3
X_913_ clknet_2_1__leaf_clk _031_ _057_ VGND VGND VPWR VPWR mult_reg\[9\] sky130_fd_sc_hd__dfrtp_1
X_775_ mult_reg\[1\] net25 VGND VGND VPWR VPWR _381_ sky130_fd_sc_hd__and2_1
X_844_ mult_reg\[0\] net18 VGND VGND VPWR VPWR _436_ sky130_fd_sc_hd__or2_1
XFILLER_0_37_160 VGND VGND VPWR VPWR sky130_fd_sc_hd__decap_8
XFILLER_0_45_51 VGND VGND VPWR VPWR sky130_fd_sc_hd__decap_4
XFILLER_0_0_53 VGND VGND VPWR VPWR sky130_fd_sc_hd__decap_3
XFILLER_0_0_97 VGND VGND VPWR VPWR sky130_fd_sc_hd__decap_4
XFILLER_0_28_182 VPWR VGND VPWR VGND sky130_ef_sc_hd__decap_12
XFILLER_0_3_293 VGND VGND VPWR VPWR sky130_fd_sc_hd__decap_6
X_560_ _175_ _177_ VGND VGND VPWR VPWR _028_ sky130_fd_sc_hd__xnor2_1
X_491_ _109_ _110_ VGND VGND VPWR VPWR _111_ sky130_fd_sc_hd__and2b_1
XFILLER_0_34_141 VGND VGND VPWR VPWR sky130_fd_sc_hd__decap_6
X_827_ mult_reg\[12\] net21 VGND VGND VPWR VPWR _423_ sky130_fd_sc_hd__nor2_1
X_689_ _281_ _302_ VGND VGND VPWR VPWR _303_ sky130_fd_sc_hd__xnor2_1
X_758_ _347_ _353_ VGND VGND VPWR VPWR _369_ sky130_fd_sc_hd__nor2_1
XFILLER_0_15_98 VGND VGND VPWR VPWR sky130_fd_sc_hd__decap_3
XFILLER_0_40_177 VPWR VGND VPWR VGND sky130_ef_sc_hd__decap_12
XFILLER_0_40_133 VGND VGND VPWR VPWR sky130_fd_sc_hd__decap_6
XFILLER_0_16_141 VPWR VGND VPWR VGND sky130_ef_sc_hd__decap_12
XFILLER_0_31_111 VGND VGND VPWR VPWR sky130_fd_sc_hd__fill_1
X_612_ _226_ _227_ VGND VGND VPWR VPWR _228_ sky130_fd_sc_hd__nor2_1
X_543_ _122_ _123_ _124_ VGND VGND VPWR VPWR _161_ sky130_fd_sc_hd__a21bo_1
X_474_ _090_ _091_ _092_ VGND VGND VPWR VPWR _094_ sky130_fd_sc_hd__a21o_1
XFILLER_0_42_41 VPWR VGND VPWR VGND sky130_ef_sc_hd__decap_12
XFILLER_0_45_225 VPWR VGND VPWR VGND sky130_ef_sc_hd__decap_12
XFILLER_0_42_85 VPWR VGND VPWR VGND sky130_ef_sc_hd__decap_12
XFILLER_0_6_85 VPWR VGND VPWR VGND sky130_ef_sc_hd__decap_12
XFILLER_0_6_41 VPWR VGND VPWR VGND sky130_ef_sc_hd__decap_12
XFILLER_0_13_177 VGND VGND VPWR VPWR sky130_fd_sc_hd__decap_6
XFILLER_0_13_199 VPWR VGND VPWR VGND sky130_ef_sc_hd__decap_12
XPHY_12 VGND VGND VPWR VPWR sky130_fd_sc_hd__decap_3
XPHY_89 VGND VGND VPWR VPWR sky130_fd_sc_hd__decap_3
XPHY_78 VGND VGND VPWR VPWR sky130_fd_sc_hd__decap_3
XPHY_67 VGND VGND VPWR VPWR sky130_fd_sc_hd__decap_3
XPHY_23 VGND VGND VPWR VPWR sky130_fd_sc_hd__decap_3
XPHY_34 VGND VGND VPWR VPWR sky130_fd_sc_hd__decap_3
XPHY_45 VGND VGND VPWR VPWR sky130_fd_sc_hd__decap_3
XPHY_56 VGND VGND VPWR VPWR sky130_fd_sc_hd__decap_3
X_526_ _133_ VGND VGND VPWR VPWR _144_ sky130_fd_sc_hd__inv_2
X_457_ net14 VGND VGND VPWR VPWR _077_ sky130_fd_sc_hd__buf_6
XFILLER_0_37_85 VGND VGND VPWR VPWR sky130_fd_sc_hd__decap_8
XFILLER_0_41_261 VPWR VGND VPWR VGND sky130_ef_sc_hd__decap_12
XTAP_180 VGND VPWR sky130_fd_sc_hd__tapvpwrvgnd_1
XTAP_191 VGND VPWR sky130_fd_sc_hd__tapvpwrvgnd_1
X_509_ _125_ _126_ _127_ VGND VGND VPWR VPWR _128_ sky130_fd_sc_hd__nand3_1
XFILLER_0_23_54 VGND VGND VPWR VPWR sky130_fd_sc_hd__fill_2
XFILLER_0_2_133 VGND VGND VPWR VPWR sky130_fd_sc_hd__decap_6
XFILLER_0_15_217 VGND VGND VPWR VPWR sky130_fd_sc_hd__decap_6
XFILLER_0_2_177 VPWR VGND VPWR VGND sky130_ef_sc_hd__decap_12
X_860_ _441_ VGND VGND VPWR VPWR _038_ sky130_fd_sc_hd__inv_2
X_791_ _390_ _391_ _392_ VGND VGND VPWR VPWR _394_ sky130_fd_sc_hd__o21a_1
XFILLER_0_12_209 VPWR VGND VPWR VGND sky130_ef_sc_hd__decap_12
XFILLER_0_20_242 VGND VGND VPWR VPWR sky130_fd_sc_hd__decap_8
XFILLER_0_20_253 VPWR VGND VPWR VGND sky130_ef_sc_hd__decap_12
XFILLER_0_20_297 VGND VGND VPWR VPWR sky130_fd_sc_hd__fill_2
XFILLER_0_18_98 VPWR VGND VPWR VGND sky130_ef_sc_hd__decap_12
XFILLER_0_7_225 VPWR VGND VPWR VGND sky130_ef_sc_hd__decap_12
XFILLER_0_38_106 VGND VGND VPWR VPWR sky130_fd_sc_hd__fill_1
X_912_ clknet_2_3__leaf_clk _030_ _056_ VGND VGND VPWR VPWR mult_reg\[8\] sky130_fd_sc_hd__dfrtp_1
X_843_ _434_ _435_ VGND VGND VPWR VPWR _006_ sky130_fd_sc_hd__xnor2_1
X_774_ _379_ _380_ VGND VGND VPWR VPWR _007_ sky130_fd_sc_hd__xnor2_1
XFILLER_0_44_109 VPWR VGND VPWR VGND sky130_ef_sc_hd__decap_12
XFILLER_0_29_139 VGND VGND VPWR VPWR sky130_fd_sc_hd__fill_1
XFILLER_0_29_53 VGND VGND VPWR VPWR sky130_fd_sc_hd__decap_3
XFILLER_0_29_64 VGND VGND VPWR VPWR sky130_fd_sc_hd__decap_4
XFILLER_0_0_21 VGND VGND VPWR VPWR sky130_fd_sc_hd__decap_3
XFILLER_0_0_65 VPWR VGND VPWR VGND sky130_ef_sc_hd__decap_12
XFILLER_0_9_85 VGND VGND VPWR VPWR sky130_fd_sc_hd__fill_1
XFILLER_0_28_194 VGND VGND VPWR VPWR sky130_fd_sc_hd__fill_2
XFILLER_0_3_261 VPWR VGND VPWR VGND sky130_ef_sc_hd__decap_12
X_490_ _084_ _072_ _079_ _065_ VGND VGND VPWR VPWR _110_ sky130_fd_sc_hd__and4_1
X_826_ _419_ _421_ _418_ VGND VGND VPWR VPWR _422_ sky130_fd_sc_hd__a21boi_1
Xclkbuf_2_3__f_clk clknet_0_clk VGND VGND VPWR VPWR clknet_2_3__leaf_clk sky130_fd_sc_hd__clkbuf_16
X_688_ _300_ _301_ VGND VGND VPWR VPWR _302_ sky130_fd_sc_hd__or2_1
X_757_ _366_ _367_ VGND VGND VPWR VPWR _368_ sky130_fd_sc_hd__nor2_1
XFILLER_0_31_54 VGND VGND VPWR VPWR sky130_fd_sc_hd__fill_2
XFILLER_0_31_87 VGND VGND VPWR VPWR sky130_fd_sc_hd__fill_1
XFILLER_0_40_189 VGND VGND VPWR VPWR sky130_fd_sc_hd__decap_6
XFILLER_0_0_253 VPWR VGND VPWR VGND sky130_ef_sc_hd__decap_12
XFILLER_0_15_3 VPWR VGND VPWR VGND sky130_ef_sc_hd__decap_12
XFILLER_0_16_153 VPWR VGND VPWR VGND sky130_ef_sc_hd__decap_12
XFILLER_0_31_167 VGND VGND VPWR VPWR sky130_fd_sc_hd__fill_1
XFILLER_0_39_223 VGND VGND VPWR VPWR sky130_fd_sc_hd__fill_1
X_611_ _064_ _077_ net5 net6 VGND VGND VPWR VPWR _227_ sky130_fd_sc_hd__and4_1
X_542_ _072_ _116_ _157_ _158_ VGND VGND VPWR VPWR _160_ sky130_fd_sc_hd__a22o_1
X_473_ _090_ _091_ _092_ VGND VGND VPWR VPWR _093_ sky130_fd_sc_hd__nand3_1
XFILLER_0_22_145 VPWR VGND VPWR VGND sky130_ef_sc_hd__decap_12
X_809_ _407_ _408_ VGND VGND VPWR VPWR _409_ sky130_fd_sc_hd__and2b_1
XFILLER_0_45_237 VPWR VGND VPWR VGND sky130_ef_sc_hd__decap_12
XFILLER_0_42_53 VPWR VGND VPWR VGND sky130_ef_sc_hd__decap_12
XFILLER_0_42_97 VPWR VGND VPWR VGND sky130_ef_sc_hd__decap_12
XFILLER_0_6_97 VPWR VGND VPWR VGND sky130_ef_sc_hd__decap_12
XFILLER_0_6_53 VPWR VGND VPWR VGND sky130_ef_sc_hd__decap_12
XPHY_13 VGND VGND VPWR VPWR sky130_fd_sc_hd__decap_3
XPHY_24 VGND VGND VPWR VPWR sky130_fd_sc_hd__decap_3
XPHY_35 VGND VGND VPWR VPWR sky130_fd_sc_hd__decap_3
XPHY_46 VGND VGND VPWR VPWR sky130_fd_sc_hd__decap_3
XPHY_79 VGND VGND VPWR VPWR sky130_fd_sc_hd__decap_3
XPHY_68 VGND VGND VPWR VPWR sky130_fd_sc_hd__decap_3
XFILLER_0_8_161 VGND VGND VPWR VPWR sky130_fd_sc_hd__fill_2
XPHY_57 VGND VGND VPWR VPWR sky130_fd_sc_hd__decap_3
XFILLER_0_4_3 VPWR VGND VPWR VGND sky130_ef_sc_hd__decap_12
X_456_ _066_ _074_ _075_ VGND VGND VPWR VPWR _076_ sky130_fd_sc_hd__o21bai_1
X_525_ _135_ _136_ VGND VGND VPWR VPWR _143_ sky130_fd_sc_hd__or2_4
XFILLER_0_35_281 VGND VGND VPWR VPWR sky130_fd_sc_hd__fill_1
XFILLER_0_6_109 VPWR VGND VPWR VGND sky130_ef_sc_hd__decap_12
XFILLER_0_12_45 VGND VGND VPWR VPWR sky130_fd_sc_hd__fill_2
XFILLER_0_27_237 VPWR VGND VPWR VGND sky130_ef_sc_hd__decap_12
XFILLER_0_10_104 VPWR VGND VPWR VGND sky130_ef_sc_hd__decap_12
XFILLER_0_10_126 VGND VGND VPWR VPWR sky130_fd_sc_hd__decap_3
XFILLER_0_41_273 VGND VGND VPWR VPWR sky130_fd_sc_hd__decap_6
XTAP_170 VGND VPWR sky130_fd_sc_hd__tapvpwrvgnd_1
XTAP_181 VGND VPWR sky130_fd_sc_hd__tapvpwrvgnd_1
XTAP_192 VGND VPWR sky130_fd_sc_hd__tapvpwrvgnd_1
XFILLER_0_17_281 VPWR VGND VPWR VGND sky130_ef_sc_hd__decap_12
X_508_ _083_ _089_ _088_ VGND VGND VPWR VPWR _127_ sky130_fd_sc_hd__a21bo_1
XFILLER_0_23_22 VPWR VGND VPWR VGND sky130_ef_sc_hd__decap_12
XFILLER_0_2_189 VGND VGND VPWR VPWR sky130_fd_sc_hd__decap_6
X_790_ _390_ _393_ VGND VGND VPWR VPWR _010_ sky130_fd_sc_hd__xnor2_1
XFILLER_0_18_66 VGND VGND VPWR VPWR sky130_fd_sc_hd__decap_3
XFILLER_0_20_265 VPWR VGND VPWR VGND sky130_ef_sc_hd__decap_12
XFILLER_0_7_237 VPWR VGND VPWR VGND sky130_ef_sc_hd__decap_12
XFILLER_0_45_3 VPWR VGND VPWR VGND sky130_ef_sc_hd__decap_12
XFILLER_0_46_173 VPWR VGND VPWR VGND sky130_ef_sc_hd__decap_12
X_911_ clknet_2_3__leaf_clk _029_ _055_ VGND VGND VPWR VPWR mult_reg\[7\] sky130_fd_sc_hd__dfrtp_1
X_842_ mult_reg\[15\] net24 VGND VGND VPWR VPWR _435_ sky130_fd_sc_hd__xnor2_1
X_773_ mult_reg\[1\] net25 VGND VGND VPWR VPWR _380_ sky130_fd_sc_hd__xor2_2
XFILLER_0_37_140 VGND VGND VPWR VPWR sky130_fd_sc_hd__fill_1
XFILLER_0_20_23 VGND VGND VPWR VPWR sky130_fd_sc_hd__fill_2
XFILLER_0_29_129 VGND VGND VPWR VPWR sky130_fd_sc_hd__fill_1
XFILLER_0_31_9 VGND VGND VPWR VPWR sky130_fd_sc_hd__fill_1
XFILLER_0_0_77 VGND VGND VPWR VPWR sky130_fd_sc_hd__decap_6
XFILLER_0_9_53 VGND VGND VPWR VPWR sky130_fd_sc_hd__decap_3
XFILLER_0_3_273 VGND VGND VPWR VPWR sky130_fd_sc_hd__decap_6
X_825_ _420_ net42 VGND VGND VPWR VPWR _002_ sky130_fd_sc_hd__xnor2_1
X_756_ _342_ _355_ _364_ VGND VGND VPWR VPWR _367_ sky130_fd_sc_hd__a21oi_1
X_687_ _282_ _269_ _299_ VGND VGND VPWR VPWR _301_ sky130_fd_sc_hd__and3_1
XFILLER_0_0_265 VPWR VGND VPWR VGND sky130_ef_sc_hd__decap_12
XFILLER_0_0_287 VGND VGND VPWR VPWR sky130_fd_sc_hd__decap_8
XFILLER_0_16_165 VPWR VGND VPWR VGND sky130_ef_sc_hd__decap_12
XFILLER_0_31_113 VPWR VGND VPWR VGND sky130_ef_sc_hd__decap_12
XFILLER_0_31_179 VGND VGND VPWR VPWR sky130_fd_sc_hd__fill_1
X_610_ _077_ _078_ _145_ _064_ VGND VGND VPWR VPWR _226_ sky130_fd_sc_hd__a22oi_1
X_541_ _072_ _116_ _157_ _158_ VGND VGND VPWR VPWR _159_ sky130_fd_sc_hd__nand4_1
X_472_ _067_ _069_ _068_ VGND VGND VPWR VPWR _092_ sky130_fd_sc_hd__a21bo_1
XFILLER_0_39_279 VGND VGND VPWR VPWR sky130_fd_sc_hd__fill_1
XFILLER_0_22_157 VGND VGND VPWR VPWR sky130_fd_sc_hd__decap_8
X_808_ mult_reg\[8\] net32 VGND VGND VPWR VPWR _408_ sky130_fd_sc_hd__nand2_1
XFILLER_0_26_99 VGND VGND VPWR VPWR sky130_fd_sc_hd__decap_6
X_739_ _304_ _350_ _329_ VGND VGND VPWR VPWR _351_ sky130_fd_sc_hd__a21o_1
XFILLER_0_45_249 VPWR VGND VPWR VGND sky130_ef_sc_hd__decap_12
XFILLER_0_45_205 VPWR VGND VPWR VGND sky130_ef_sc_hd__decap_12
XFILLER_0_42_65 VPWR VGND VPWR VGND sky130_ef_sc_hd__decap_12
XFILLER_0_42_21 VGND VGND VPWR VPWR sky130_fd_sc_hd__decap_6
XFILLER_0_13_157 VGND VGND VPWR VPWR sky130_fd_sc_hd__decap_8
XTAP_330 VGND VPWR sky130_fd_sc_hd__tapvpwrvgnd_1
XFILLER_0_6_65 VPWR VGND VPWR VGND sky130_ef_sc_hd__decap_12
XPHY_69 VGND VGND VPWR VPWR sky130_fd_sc_hd__decap_3
Xrebuffer10 _250_ VGND VGND VPWR VPWR net43 sky130_fd_sc_hd__clkbuf_1
XPHY_14 VGND VGND VPWR VPWR sky130_fd_sc_hd__decap_3
XPHY_25 VGND VGND VPWR VPWR sky130_fd_sc_hd__decap_3
XPHY_36 VGND VGND VPWR VPWR sky130_fd_sc_hd__decap_3
XPHY_47 VGND VGND VPWR VPWR sky130_fd_sc_hd__decap_3
XPHY_58 VGND VGND VPWR VPWR sky130_fd_sc_hd__decap_3
X_524_ _142_ VGND VGND VPWR VPWR _027_ sky130_fd_sc_hd__clkbuf_1
X_455_ _070_ _071_ _073_ VGND VGND VPWR VPWR _075_ sky130_fd_sc_hd__and3_1
XFILLER_0_27_249 VPWR VGND VPWR VGND sky130_ef_sc_hd__decap_12
XFILLER_0_10_116 VGND VGND VPWR VPWR sky130_fd_sc_hd__decap_3
XTAP_160 VGND VPWR sky130_fd_sc_hd__tapvpwrvgnd_1
XTAP_171 VGND VPWR sky130_fd_sc_hd__tapvpwrvgnd_1
XTAP_182 VGND VPWR sky130_fd_sc_hd__tapvpwrvgnd_1
XTAP_193 VGND VPWR sky130_fd_sc_hd__tapvpwrvgnd_1
XFILLER_0_17_293 VGND VGND VPWR VPWR sky130_fd_sc_hd__fill_2
X_507_ _123_ _124_ _122_ VGND VGND VPWR VPWR _126_ sky130_fd_sc_hd__a21o_1
XFILLER_0_23_34 VPWR VGND VPWR VGND sky130_ef_sc_hd__decap_12
XFILLER_0_23_89 VGND VGND VPWR VPWR sky130_fd_sc_hd__decap_3
Xrebuffer1 _353_ VGND VGND VPWR VPWR net34 sky130_fd_sc_hd__clkbuf_1
XFILLER_0_3_55 VGND VGND VPWR VPWR sky130_fd_sc_hd__fill_1
XFILLER_0_14_241 VGND VGND VPWR VPWR sky130_fd_sc_hd__decap_8
XFILLER_0_20_200 VPWR VGND VPWR VGND sky130_ef_sc_hd__decap_12
XFILLER_0_20_222 VPWR VGND VPWR VGND sky130_ef_sc_hd__decap_12
XFILLER_0_18_23 VGND VGND VPWR VPWR sky130_fd_sc_hd__fill_1
XFILLER_0_20_277 VPWR VGND VPWR VGND sky130_ef_sc_hd__decap_12
XFILLER_0_7_205 VPWR VGND VPWR VGND sky130_ef_sc_hd__decap_12
XFILLER_0_7_249 VPWR VGND VPWR VGND sky130_ef_sc_hd__decap_12
XFILLER_0_38_3 VPWR VGND VPWR VGND sky130_ef_sc_hd__decap_12
XFILLER_0_46_185 VGND VGND VPWR VPWR sky130_fd_sc_hd__decap_8
XFILLER_0_46_141 VPWR VGND VPWR VGND sky130_ef_sc_hd__decap_12
X_841_ _431_ _433_ _430_ VGND VGND VPWR VPWR _434_ sky130_fd_sc_hd__o21bai_1
X_910_ clknet_2_2__leaf_clk _028_ _054_ VGND VGND VPWR VPWR mult_reg\[6\] sky130_fd_sc_hd__dfrtp_1
X_772_ mult_reg\[0\] net18 VGND VGND VPWR VPWR _379_ sky130_fd_sc_hd__nand2_1
XFILLER_0_37_130 VGND VGND VPWR VPWR sky130_fd_sc_hd__fill_1
XFILLER_0_20_46 VPWR VGND VPWR VGND sky130_ef_sc_hd__decap_12
XFILLER_0_29_33 VPWR VGND VPWR VGND sky130_ef_sc_hd__decap_12
XFILLER_0_43_111 VGND VGND VPWR VPWR sky130_fd_sc_hd__fill_1
XFILLER_0_9_21 VPWR VGND VPWR VGND sky130_ef_sc_hd__decap_12
XFILLER_0_9_98 VPWR VGND VPWR VGND sky130_ef_sc_hd__decap_12
XFILLER_0_19_163 VGND VGND VPWR VPWR sky130_fd_sc_hd__decap_4
X_824_ _414_ _417_ _415_ VGND VGND VPWR VPWR _421_ sky130_fd_sc_hd__o21ai_1
X_755_ _365_ VGND VGND VPWR VPWR _366_ sky130_fd_sc_hd__inv_2
X_686_ _282_ _269_ _299_ VGND VGND VPWR VPWR _300_ sky130_fd_sc_hd__a21oi_2
XFILLER_0_25_111 VGND VGND VPWR VPWR sky130_fd_sc_hd__fill_1
XFILLER_0_25_155 VGND VGND VPWR VPWR sky130_fd_sc_hd__decap_6
XFILLER_0_25_199 VPWR VGND VPWR VGND sky130_ef_sc_hd__decap_12
XFILLER_0_0_277 VGND VGND VPWR VPWR sky130_fd_sc_hd__decap_3
XFILLER_0_16_177 VPWR VGND VPWR VGND sky130_ef_sc_hd__decap_12
XFILLER_0_31_125 VGND VGND VPWR VPWR sky130_fd_sc_hd__fill_1
XFILLER_0_31_169 VGND VGND VPWR VPWR sky130_fd_sc_hd__decap_4
X_540_ net4 net3 net13 net14 VGND VGND VPWR VPWR _158_ sky130_fd_sc_hd__nand4_1
XFILLER_0_39_225 VPWR VGND VPWR VGND sky130_ef_sc_hd__decap_12
X_471_ _088_ _089_ _083_ VGND VGND VPWR VPWR _091_ sky130_fd_sc_hd__a21o_1
X_807_ mult_reg\[8\] net32 VGND VGND VPWR VPWR _407_ sky130_fd_sc_hd__nor2_1
X_669_ _064_ _181_ VGND VGND VPWR VPWR _283_ sky130_fd_sc_hd__nand2_1
X_738_ _300_ _309_ _327_ VGND VGND VPWR VPWR _350_ sky130_fd_sc_hd__or3_1
XFILLER_0_45_217 VGND VGND VPWR VPWR sky130_fd_sc_hd__decap_6
XFILLER_0_42_77 VGND VGND VPWR VPWR sky130_fd_sc_hd__decap_6
XFILLER_0_13_169 VGND VGND VPWR VPWR sky130_fd_sc_hd__fill_1
XTAP_331 VGND VPWR sky130_fd_sc_hd__tapvpwrvgnd_1
XTAP_320 VGND VPWR sky130_fd_sc_hd__tapvpwrvgnd_1
Xrebuffer11 _402_ VGND VGND VPWR VPWR net44 sky130_fd_sc_hd__clkbuf_1
XFILLER_0_6_77 VGND VGND VPWR VPWR sky130_fd_sc_hd__decap_6
XFILLER_0_20_3 VPWR VGND VPWR VGND sky130_ef_sc_hd__decap_12
XPHY_15 VGND VGND VPWR VPWR sky130_fd_sc_hd__decap_3
XPHY_26 VGND VGND VPWR VPWR sky130_fd_sc_hd__decap_3
XPHY_37 VGND VGND VPWR VPWR sky130_fd_sc_hd__decap_3
XPHY_48 VGND VGND VPWR VPWR sky130_fd_sc_hd__decap_3
XPHY_59 VGND VGND VPWR VPWR sky130_fd_sc_hd__decap_3
XFILLER_0_8_141 VPWR VGND VPWR VGND sky130_ef_sc_hd__decap_12
X_523_ _140_ _141_ VGND VGND VPWR VPWR _142_ sky130_fd_sc_hd__and2_1
XFILLER_0_42_209 VPWR VGND VPWR VGND sky130_ef_sc_hd__decap_12
XFILLER_0_12_69 VPWR VGND VPWR VGND sky130_ef_sc_hd__decap_12
X_454_ _070_ _071_ _073_ VGND VGND VPWR VPWR _074_ sky130_fd_sc_hd__a21oi_1
XFILLER_0_27_228 VGND VGND VPWR VPWR sky130_fd_sc_hd__decap_4
XFILLER_0_37_55 VGND VGND VPWR VPWR sky130_fd_sc_hd__fill_1
XFILLER_0_5_111 VGND VGND VPWR VPWR sky130_fd_sc_hd__fill_1
XFILLER_0_18_239 VPWR VGND VPWR VGND sky130_ef_sc_hd__decap_12
XFILLER_0_26_294 VGND VGND VPWR VPWR sky130_fd_sc_hd__decap_4
XTAP_150 VGND VPWR sky130_fd_sc_hd__tapvpwrvgnd_1
XTAP_161 VGND VPWR sky130_fd_sc_hd__tapvpwrvgnd_1
XTAP_172 VGND VPWR sky130_fd_sc_hd__tapvpwrvgnd_1
XTAP_183 VGND VPWR sky130_fd_sc_hd__tapvpwrvgnd_1
XTAP_194 VGND VPWR sky130_fd_sc_hd__tapvpwrvgnd_1
XFILLER_0_32_253 VPWR VGND VPWR VGND sky130_ef_sc_hd__decap_12
X_506_ _122_ _123_ _124_ VGND VGND VPWR VPWR _125_ sky130_fd_sc_hd__nand3_1
XFILLER_0_23_46 VGND VGND VPWR VPWR sky130_fd_sc_hd__decap_8
Xrebuffer2 _251_ VGND VGND VPWR VPWR net35 sky130_fd_sc_hd__clkbuf_1
XFILLER_0_23_57 VPWR VGND VPWR VGND sky130_ef_sc_hd__decap_12
XFILLER_0_23_253 VGND VGND VPWR VPWR sky130_fd_sc_hd__fill_2
XFILLER_0_23_275 VGND VGND VPWR VPWR sky130_fd_sc_hd__decap_4
XFILLER_0_14_253 VPWR VGND VPWR VGND sky130_ef_sc_hd__decap_12
XFILLER_0_14_297 VGND VGND VPWR VPWR sky130_fd_sc_hd__fill_2
XFILLER_0_20_234 VGND VGND VPWR VPWR sky130_fd_sc_hd__fill_2
XFILLER_0_20_289 VGND VGND VPWR VPWR sky130_fd_sc_hd__decap_8
XFILLER_0_18_46 VPWR VGND VPWR VGND sky130_ef_sc_hd__decap_12
XFILLER_0_7_217 VGND VGND VPWR VPWR sky130_fd_sc_hd__decap_6
XFILLER_0_46_197 VGND VGND VPWR VPWR sky130_fd_sc_hd__fill_2
XFILLER_0_46_153 VPWR VGND VPWR VGND sky130_ef_sc_hd__decap_12
X_840_ _432_ _433_ VGND VGND VPWR VPWR _005_ sky130_fd_sc_hd__xnor2_1
X_771_ _378_ VGND VGND VPWR VPWR _016_ sky130_fd_sc_hd__clkbuf_1
XFILLER_0_4_209 VPWR VGND VPWR VGND sky130_ef_sc_hd__decap_12
XFILLER_0_20_58 VPWR VGND VPWR VGND sky130_ef_sc_hd__decap_12
XFILLER_0_29_45 VGND VGND VPWR VPWR sky130_fd_sc_hd__decap_8
XFILLER_0_45_55 VGND VGND VPWR VPWR sky130_fd_sc_hd__fill_1
XFILLER_0_0_13 VGND VGND VPWR VPWR sky130_fd_sc_hd__decap_8
XFILLER_0_9_33 VPWR VGND VPWR VGND sky130_ef_sc_hd__decap_12
XFILLER_0_0_57 VGND VGND VPWR VPWR sky130_fd_sc_hd__fill_2
XFILLER_0_43_167 VGND VGND VPWR VPWR sky130_fd_sc_hd__fill_1
XFILLER_0_34_156 VGND VGND VPWR VPWR sky130_fd_sc_hd__fill_1
XFILLER_0_19_153 VGND VGND VPWR VPWR sky130_fd_sc_hd__fill_2
X_823_ _418_ _419_ VGND VGND VPWR VPWR _420_ sky130_fd_sc_hd__nand2_1
X_685_ _288_ _298_ VGND VGND VPWR VPWR _299_ sky130_fd_sc_hd__xnor2_1
X_754_ _342_ _355_ _364_ VGND VGND VPWR VPWR _365_ sky130_fd_sc_hd__nand3_1
XFILLER_0_31_46 VGND VGND VPWR VPWR sky130_fd_sc_hd__decap_8
XFILLER_0_31_57 VGND VGND VPWR VPWR sky130_fd_sc_hd__fill_2
XFILLER_0_0_245 VGND VGND VPWR VPWR sky130_fd_sc_hd__fill_1
XFILLER_0_16_189 VGND VGND VPWR VPWR sky130_fd_sc_hd__decap_6
XFILLER_0_39_237 VPWR VGND VPWR VGND sky130_ef_sc_hd__decap_12
X_470_ _083_ _088_ _089_ VGND VGND VPWR VPWR _090_ sky130_fd_sc_hd__nand3_1
XFILLER_0_22_126 VGND VGND VPWR VPWR sky130_fd_sc_hd__decap_8
X_806_ _402_ _403_ _404_ VGND VGND VPWR VPWR _406_ sky130_fd_sc_hd__o21a_1
X_668_ _266_ _267_ VGND VGND VPWR VPWR _282_ sky130_fd_sc_hd__or2_1
XFILLER_0_26_68 VGND VGND VPWR VPWR sky130_fd_sc_hd__fill_1
X_737_ _347_ _348_ VGND VGND VPWR VPWR _349_ sky130_fd_sc_hd__or2_1
X_599_ _180_ _209_ VGND VGND VPWR VPWR _215_ sky130_fd_sc_hd__nor2_1
XTAP_332 VGND VPWR sky130_fd_sc_hd__tapvpwrvgnd_1
XTAP_321 VGND VPWR sky130_fd_sc_hd__tapvpwrvgnd_1
XTAP_310 VGND VPWR sky130_fd_sc_hd__tapvpwrvgnd_1
XFILLER_0_13_3 VPWR VGND VPWR VGND sky130_ef_sc_hd__decap_12
XFILLER_0_8_153 VGND VGND VPWR VPWR sky130_fd_sc_hd__decap_8
XPHY_16 VGND VGND VPWR VPWR sky130_fd_sc_hd__decap_3
XPHY_27 VGND VGND VPWR VPWR sky130_fd_sc_hd__decap_3
XPHY_38 VGND VGND VPWR VPWR sky130_fd_sc_hd__decap_3
XPHY_49 VGND VGND VPWR VPWR sky130_fd_sc_hd__decap_3
XFILLER_0_44_251 VGND VGND VPWR VPWR sky130_fd_sc_hd__fill_1
XFILLER_0_8_197 VPWR VGND VPWR VGND sky130_ef_sc_hd__decap_12
X_453_ net11 net3 _072_ net10 VGND VGND VPWR VPWR _073_ sky130_fd_sc_hd__and4_1
X_522_ net39 _138_ _139_ VGND VGND VPWR VPWR _141_ sky130_fd_sc_hd__nand3_1
XFILLER_0_12_15 VPWR VGND VPWR VGND sky130_ef_sc_hd__decap_12
XFILLER_0_12_37 VGND VGND VPWR VPWR sky130_fd_sc_hd__decap_8
XFILLER_0_5_167 VGND VGND VPWR VPWR sky130_fd_sc_hd__fill_1
XTAP_140 VGND VPWR sky130_fd_sc_hd__tapvpwrvgnd_1
XTAP_151 VGND VPWR sky130_fd_sc_hd__tapvpwrvgnd_1
XTAP_162 VGND VPWR sky130_fd_sc_hd__tapvpwrvgnd_1
XTAP_173 VGND VPWR sky130_fd_sc_hd__tapvpwrvgnd_1
XTAP_184 VGND VPWR sky130_fd_sc_hd__tapvpwrvgnd_1
XTAP_195 VGND VPWR sky130_fd_sc_hd__tapvpwrvgnd_1
XFILLER_0_32_298 VGND VGND VPWR VPWR sky130_fd_sc_hd__fill_1
XFILLER_0_32_265 VGND VGND VPWR VPWR sky130_fd_sc_hd__decap_4
XFILLER_0_32_221 VGND VGND VPWR VPWR sky130_fd_sc_hd__decap_3
X_505_ _085_ _086_ _087_ _064_ VGND VGND VPWR VPWR _124_ sky130_fd_sc_hd__nand4_2
XFILLER_0_23_69 VPWR VGND VPWR VGND sky130_ef_sc_hd__decap_12
Xrebuffer3 _308_ VGND VGND VPWR VPWR net36 sky130_fd_sc_hd__clkbuf_1
XFILLER_0_3_57 VPWR VGND VPWR VGND sky130_ef_sc_hd__decap_12
XFILLER_0_14_265 VPWR VGND VPWR VGND sky130_ef_sc_hd__decap_12
XFILLER_0_1_181 VPWR VGND VPWR VGND sky130_ef_sc_hd__decap_12
XFILLER_0_9_281 VPWR VGND VPWR VGND sky130_ef_sc_hd__decap_12
XFILLER_0_34_46 VPWR VGND VPWR VGND sky130_ef_sc_hd__decap_12
XFILLER_0_18_58 VGND VGND VPWR VPWR sky130_fd_sc_hd__decap_8
XFILLER_0_11_279 VGND VGND VPWR VPWR sky130_fd_sc_hd__fill_1
XFILLER_0_46_165 VGND VGND VPWR VPWR sky130_fd_sc_hd__decap_3
XFILLER_0_6_251 VGND VGND VPWR VPWR sky130_fd_sc_hd__fill_1
X_770_ _079_ _065_ VGND VGND VPWR VPWR _378_ sky130_fd_sc_hd__and2_1
XFILLER_0_20_15 VGND VGND VPWR VPWR sky130_fd_sc_hd__decap_8
X_899_ clknet_2_1__leaf_clk _002_ _043_ VGND VGND VPWR VPWR net20 sky130_fd_sc_hd__dfrtp_1
XFILLER_0_43_113 VPWR VGND VPWR VGND sky130_ef_sc_hd__decap_12
XFILLER_0_9_45 VGND VGND VPWR VPWR sky130_fd_sc_hd__decap_8
XFILLER_0_28_110 VPWR VGND VPWR VGND sky130_ef_sc_hd__decap_12
XFILLER_0_28_165 VGND VGND VPWR VPWR sky130_fd_sc_hd__fill_2
XFILLER_0_43_3 VPWR VGND VPWR VGND sky130_ef_sc_hd__decap_12
XFILLER_0_19_176 VPWR VGND VPWR VGND sky130_ef_sc_hd__decap_12
X_822_ mult_reg\[11\] net20 VGND VGND VPWR VPWR _419_ sky130_fd_sc_hd__or2_1
X_684_ _295_ _297_ VGND VGND VPWR VPWR _298_ sky130_fd_sc_hd__xnor2_1
XFILLER_0_15_15 VPWR VGND VPWR VGND sky130_ef_sc_hd__decap_12
XFILLER_0_15_37 VGND VGND VPWR VPWR sky130_fd_sc_hd__fill_2
X_753_ _362_ _363_ VGND VGND VPWR VPWR _364_ sky130_fd_sc_hd__or2_1
XFILLER_0_25_113 VGND VGND VPWR VPWR sky130_fd_sc_hd__decap_4
XFILLER_0_31_36 VGND VGND VPWR VPWR sky130_fd_sc_hd__decap_3
XFILLER_0_21_80 VPWR VGND VPWR VGND sky130_ef_sc_hd__decap_12
XFILLER_0_31_105 VGND VGND VPWR VPWR sky130_fd_sc_hd__decap_6
XFILLER_0_39_205 VPWR VGND VPWR VGND sky130_ef_sc_hd__decap_12
XFILLER_0_39_249 VPWR VGND VPWR VGND sky130_ef_sc_hd__decap_12
X_805_ net44 _405_ VGND VGND VPWR VPWR _013_ sky130_fd_sc_hd__xnor2_1
X_736_ _332_ _325_ _346_ VGND VGND VPWR VPWR _348_ sky130_fd_sc_hd__nor3_1
X_667_ _147_ _227_ _253_ _255_ VGND VGND VPWR VPWR _281_ sky130_fd_sc_hd__o2bb2ai_1
X_598_ _207_ _208_ VGND VGND VPWR VPWR _214_ sky130_fd_sc_hd__and2b_1
XANTENNA_1 net31 VGND VGND VPWR VPWR sky130_fd_sc_hd__diode_2
XFILLER_0_13_127 VPWR VGND VPWR VGND sky130_ef_sc_hd__decap_12
XTAP_333 VGND VPWR sky130_fd_sc_hd__tapvpwrvgnd_1
XTAP_322 VGND VPWR sky130_fd_sc_hd__tapvpwrvgnd_1
XTAP_311 VGND VPWR sky130_fd_sc_hd__tapvpwrvgnd_1
XTAP_300 VGND VPWR sky130_fd_sc_hd__tapvpwrvgnd_1
XPHY_17 VGND VGND VPWR VPWR sky130_fd_sc_hd__decap_3
XPHY_28 VGND VGND VPWR VPWR sky130_fd_sc_hd__decap_3
XFILLER_0_8_121 VGND VGND VPWR VPWR sky130_fd_sc_hd__fill_2
XPHY_39 VGND VGND VPWR VPWR sky130_fd_sc_hd__decap_3
XFILLER_0_12_182 VPWR VGND VPWR VGND sky130_ef_sc_hd__decap_12
X_452_ net2 VGND VGND VPWR VPWR _072_ sky130_fd_sc_hd__buf_4
X_521_ _138_ _139_ _113_ VGND VGND VPWR VPWR _140_ sky130_fd_sc_hd__a21o_1
XFILLER_0_35_285 VPWR VGND VPWR VGND sky130_ef_sc_hd__decap_12
XFILLER_0_12_27 VGND VGND VPWR VPWR sky130_fd_sc_hd__fill_1
X_719_ _330_ _331_ VGND VGND VPWR VPWR _022_ sky130_fd_sc_hd__xnor2_1
XFILLER_0_18_219 VPWR VGND VPWR VGND sky130_ef_sc_hd__decap_12
XFILLER_0_5_113 VPWR VGND VPWR VGND sky130_ef_sc_hd__decap_12
XTAP_141 VGND VPWR sky130_fd_sc_hd__tapvpwrvgnd_1
XTAP_130 VGND VPWR sky130_fd_sc_hd__tapvpwrvgnd_1
XTAP_152 VGND VPWR sky130_fd_sc_hd__tapvpwrvgnd_1
XTAP_163 VGND VPWR sky130_fd_sc_hd__tapvpwrvgnd_1
XTAP_174 VGND VPWR sky130_fd_sc_hd__tapvpwrvgnd_1
XTAP_185 VGND VPWR sky130_fd_sc_hd__tapvpwrvgnd_1
XTAP_196 VGND VPWR sky130_fd_sc_hd__tapvpwrvgnd_1
X_504_ _085_ net12 net13 _086_ VGND VGND VPWR VPWR _123_ sky130_fd_sc_hd__a22o_1
XFILLER_0_23_15 VGND VGND VPWR VPWR sky130_fd_sc_hd__fill_1
Xrebuffer4 _179_ VGND VGND VPWR VPWR net37 sky130_fd_sc_hd__clkbuf_1
XFILLER_0_3_69 VPWR VGND VPWR VGND sky130_ef_sc_hd__decap_12
XFILLER_0_1_193 VPWR VGND VPWR VGND sky130_ef_sc_hd__decap_12
XFILLER_0_14_277 VPWR VGND VPWR VGND sky130_ef_sc_hd__decap_12
XFILLER_0_9_293 VGND VGND VPWR VPWR sky130_fd_sc_hd__decap_6
XFILLER_0_18_15 VGND VGND VPWR VPWR sky130_fd_sc_hd__decap_8
XFILLER_0_34_58 VGND VGND VPWR VPWR sky130_fd_sc_hd__decap_4
XFILLER_0_11_225 VPWR VGND VPWR VGND sky130_ef_sc_hd__decap_12
XFILLER_0_46_133 VGND VGND VPWR VPWR sky130_fd_sc_hd__decap_6
XFILLER_0_46_111 VGND VGND VPWR VPWR sky130_fd_sc_hd__fill_1
XFILLER_0_37_100 VGND VGND VPWR VPWR sky130_fd_sc_hd__decap_3
X_898_ clknet_2_1__leaf_clk _001_ _042_ VGND VGND VPWR VPWR net19 sky130_fd_sc_hd__dfrtp_1
XFILLER_0_45_57 VPWR VGND VPWR VGND sky130_ef_sc_hd__decap_12
XFILLER_0_28_122 VPWR VGND VPWR VGND sky130_ef_sc_hd__decap_12
XFILLER_0_43_169 VPWR VGND VPWR VGND sky130_ef_sc_hd__decap_12
XFILLER_0_43_125 VPWR VGND VPWR VGND sky130_ef_sc_hd__decap_12
XFILLER_0_9_57 VPWR VGND VPWR VGND sky130_ef_sc_hd__decap_12
XFILLER_0_19_91 VGND VGND VPWR VPWR sky130_fd_sc_hd__fill_1
XFILLER_0_34_103 VPWR VGND VPWR VGND sky130_ef_sc_hd__decap_12
XFILLER_0_19_111 VGND VGND VPWR VPWR sky130_fd_sc_hd__fill_1
XFILLER_0_19_144 VGND VGND VPWR VPWR sky130_fd_sc_hd__decap_6
XFILLER_0_19_188 VPWR VGND VPWR VGND sky130_ef_sc_hd__decap_12
X_821_ mult_reg\[11\] net20 VGND VGND VPWR VPWR _418_ sky130_fd_sc_hd__nand2_1
X_752_ _361_ _360_ VGND VGND VPWR VPWR _363_ sky130_fd_sc_hd__and2b_1
X_683_ _263_ _264_ _296_ VGND VGND VPWR VPWR _297_ sky130_fd_sc_hd__a21oi_1
XFILLER_0_15_27 VGND VGND VPWR VPWR sky130_fd_sc_hd__decap_3
XFILLER_0_25_103 VGND VGND VPWR VPWR sky130_fd_sc_hd__decap_8
XFILLER_0_25_169 VPWR VGND VPWR VGND sky130_ef_sc_hd__decap_12
XFILLER_0_40_139 VGND VGND VPWR VPWR sky130_fd_sc_hd__fill_1
XFILLER_0_0_225 VPWR VGND VPWR VGND sky130_ef_sc_hd__decap_12
XFILLER_0_16_136 VGND VGND VPWR VPWR sky130_fd_sc_hd__decap_4
XFILLER_0_21_92 VGND VGND VPWR VPWR sky130_fd_sc_hd__decap_4
XFILLER_0_39_217 VGND VGND VPWR VPWR sky130_fd_sc_hd__decap_6
XFILLER_0_22_139 VGND VGND VPWR VPWR sky130_fd_sc_hd__fill_1
X_804_ _403_ _404_ VGND VGND VPWR VPWR _405_ sky130_fd_sc_hd__and2b_1
X_735_ _332_ _325_ _346_ VGND VGND VPWR VPWR _347_ sky130_fd_sc_hd__o21a_1
XFILLER_0_26_15 VPWR VGND VPWR VGND sky130_ef_sc_hd__decap_12
X_597_ _171_ _213_ VGND VGND VPWR VPWR _029_ sky130_fd_sc_hd__xor2_1
X_666_ _271_ _272_ _279_ VGND VGND VPWR VPWR _280_ sky130_fd_sc_hd__o21a_1
XFILLER_0_13_139 VGND VGND VPWR VPWR sky130_fd_sc_hd__decap_6
XTAP_334 VGND VPWR sky130_fd_sc_hd__tapvpwrvgnd_1
XTAP_323 VGND VPWR sky130_fd_sc_hd__tapvpwrvgnd_1
XTAP_312 VGND VPWR sky130_fd_sc_hd__tapvpwrvgnd_1
XTAP_301 VGND VPWR sky130_fd_sc_hd__tapvpwrvgnd_1
XPHY_18 VGND VGND VPWR VPWR sky130_fd_sc_hd__decap_3
XPHY_29 VGND VGND VPWR VPWR sky130_fd_sc_hd__decap_3
XFILLER_0_16_92 VGND VGND VPWR VPWR sky130_fd_sc_hd__decap_6
XFILLER_0_44_253 VPWR VGND VPWR VGND sky130_ef_sc_hd__decap_12
XFILLER_0_36_209 VPWR VGND VPWR VGND sky130_ef_sc_hd__decap_12
XFILLER_0_29_294 VGND VGND VPWR VPWR sky130_fd_sc_hd__fill_1
XFILLER_0_12_194 VGND VGND VPWR VPWR sky130_fd_sc_hd__fill_2
X_520_ _135_ _136_ _137_ VGND VGND VPWR VPWR _139_ sky130_fd_sc_hd__o21ai_1
X_451_ _068_ _069_ _067_ VGND VGND VPWR VPWR _071_ sky130_fd_sc_hd__a21o_1
XFILLER_0_35_297 VGND VGND VPWR VPWR sky130_fd_sc_hd__fill_2
XFILLER_0_35_253 VGND VGND VPWR VPWR sky130_fd_sc_hd__fill_1
XFILLER_0_37_47 VGND VGND VPWR VPWR sky130_fd_sc_hd__fill_1
X_649_ _229_ _230_ _231_ VGND VGND VPWR VPWR _264_ sky130_fd_sc_hd__a21bo_1
X_718_ _306_ net36 _304_ VGND VGND VPWR VPWR _331_ sky130_fd_sc_hd__a21oi_1
XFILLER_0_5_125 VPWR VGND VPWR VGND sky130_ef_sc_hd__decap_12
XFILLER_0_18_209 VGND VGND VPWR VPWR sky130_fd_sc_hd__decap_4
XFILLER_0_26_220 VGND VGND VPWR VPWR sky130_fd_sc_hd__fill_1
XFILLER_0_26_253 VPWR VGND VPWR VGND sky130_ef_sc_hd__decap_12
XFILLER_0_41_223 VGND VGND VPWR VPWR sky130_fd_sc_hd__fill_1
XFILLER_0_5_169 VPWR VGND VPWR VGND sky130_ef_sc_hd__decap_12
XTAP_142 VGND VPWR sky130_fd_sc_hd__tapvpwrvgnd_1
XTAP_131 VGND VPWR sky130_fd_sc_hd__tapvpwrvgnd_1
XTAP_120 VGND VPWR sky130_fd_sc_hd__tapvpwrvgnd_1
XTAP_153 VGND VPWR sky130_fd_sc_hd__tapvpwrvgnd_1
XTAP_164 VGND VPWR sky130_fd_sc_hd__tapvpwrvgnd_1
XTAP_175 VGND VPWR sky130_fd_sc_hd__tapvpwrvgnd_1
XTAP_186 VGND VPWR sky130_fd_sc_hd__tapvpwrvgnd_1
XTAP_197 VGND VPWR sky130_fd_sc_hd__tapvpwrvgnd_1
XFILLER_0_17_231 VGND VGND VPWR VPWR sky130_fd_sc_hd__fill_1
X_503_ _072_ _077_ VGND VGND VPWR VPWR _122_ sky130_fd_sc_hd__and2_1
XFILLER_0_2_139 VGND VGND VPWR VPWR sky130_fd_sc_hd__fill_1
XFILLER_0_23_245 VGND VGND VPWR VPWR sky130_fd_sc_hd__decap_8
Xrebuffer5 _173_ VGND VGND VPWR VPWR net38 sky130_fd_sc_hd__clkbuf_1
XFILLER_0_3_15 VPWR VGND VPWR VGND sky130_ef_sc_hd__decap_12
XFILLER_0_14_212 VGND VGND VPWR VPWR sky130_fd_sc_hd__decap_6
XFILLER_0_1_161 VGND VGND VPWR VPWR sky130_fd_sc_hd__decap_6
XFILLER_0_14_289 VGND VGND VPWR VPWR sky130_fd_sc_hd__decap_8
XFILLER_0_9_261 VPWR VGND VPWR VGND sky130_ef_sc_hd__decap_12
XFILLER_0_34_15 VPWR VGND VPWR VGND sky130_ef_sc_hd__decap_12
XFILLER_0_11_204 VPWR VGND VPWR VGND sky130_ef_sc_hd__decap_12
XFILLER_0_11_237 VPWR VGND VPWR VGND sky130_ef_sc_hd__decap_12
XFILLER_0_6_297 VGND VGND VPWR VPWR sky130_fd_sc_hd__fill_2
XFILLER_0_6_253 VPWR VGND VPWR VGND sky130_ef_sc_hd__decap_12
XFILLER_0_37_134 VGND VGND VPWR VPWR sky130_fd_sc_hd__decap_6
XFILLER_0_45_69 VPWR VGND VPWR VGND sky130_ef_sc_hd__decap_12
X_897_ clknet_2_3__leaf_clk _015_ _041_ VGND VGND VPWR VPWR net33 sky130_fd_sc_hd__dfrtp_1
XFILLER_0_28_134 VGND VGND VPWR VPWR sky130_fd_sc_hd__decap_6
XFILLER_0_28_156 VGND VGND VPWR VPWR sky130_fd_sc_hd__decap_3
XFILLER_0_43_137 VPWR VGND VPWR VGND sky130_ef_sc_hd__decap_12
XFILLER_0_9_69 VPWR VGND VPWR VGND sky130_ef_sc_hd__decap_12
XFILLER_0_3_223 VGND VGND VPWR VPWR sky130_fd_sc_hd__fill_1
XFILLER_0_10_83 VGND VGND VPWR VPWR sky130_fd_sc_hd__fill_1
XFILLER_0_29_3 VGND VGND VPWR VPWR sky130_fd_sc_hd__fill_1
XFILLER_0_34_115 VPWR VGND VPWR VGND sky130_ef_sc_hd__decap_12
XFILLER_0_19_134 VGND VGND VPWR VPWR sky130_fd_sc_hd__decap_3
XFILLER_0_19_167 VGND VGND VPWR VPWR sky130_fd_sc_hd__fill_1
X_820_ _414_ _417_ VGND VGND VPWR VPWR _001_ sky130_fd_sc_hd__xor2_1
X_682_ _260_ _265_ VGND VGND VPWR VPWR _296_ sky130_fd_sc_hd__and2_1
X_751_ _360_ _361_ VGND VGND VPWR VPWR _362_ sky130_fd_sc_hd__and2b_1
XFILLER_0_33_181 VGND VGND VPWR VPWR sky130_fd_sc_hd__decap_4
XFILLER_0_25_137 VGND VGND VPWR VPWR sky130_fd_sc_hd__decap_8
XFILLER_0_0_237 VGND VGND VPWR VPWR sky130_fd_sc_hd__decap_8
XFILLER_0_1_81 VPWR VGND VPWR VGND sky130_ef_sc_hd__decap_12
XFILLER_0_22_107 VPWR VGND VPWR VGND sky130_ef_sc_hd__decap_12
X_803_ mult_reg\[7\] net31 VGND VGND VPWR VPWR _404_ sky130_fd_sc_hd__nand2_1
X_734_ _343_ _345_ VGND VGND VPWR VPWR _346_ sky130_fd_sc_hd__xor2_1
XFILLER_0_26_27 VGND VGND VPWR VPWR sky130_fd_sc_hd__fill_1
X_665_ _252_ _273_ VGND VGND VPWR VPWR _279_ sky130_fd_sc_hd__or2_1
XFILLER_0_38_251 VGND VGND VPWR VPWR sky130_fd_sc_hd__fill_1
X_596_ _211_ _212_ VGND VGND VPWR VPWR _213_ sky130_fd_sc_hd__and2b_1
XFILLER_0_6_15 VPWR VGND VPWR VGND sky130_ef_sc_hd__decap_12
XTAP_335 VGND VPWR sky130_fd_sc_hd__tapvpwrvgnd_1
XTAP_324 VGND VPWR sky130_fd_sc_hd__tapvpwrvgnd_1
XTAP_313 VGND VPWR sky130_fd_sc_hd__tapvpwrvgnd_1
XTAP_302 VGND VPWR sky130_fd_sc_hd__tapvpwrvgnd_1
XPHY_19 VGND VGND VPWR VPWR sky130_fd_sc_hd__decap_3
XFILLER_0_44_265 VPWR VGND VPWR VGND sky130_ef_sc_hd__decap_12
XFILLER_0_44_221 VPWR VGND VPWR VGND sky130_ef_sc_hd__decap_12
XFILLER_0_29_273 VGND VGND VPWR VPWR sky130_fd_sc_hd__fill_1
XFILLER_0_12_162 VGND VGND VPWR VPWR sky130_fd_sc_hd__fill_1
XFILLER_0_12_29 VGND VGND VPWR VPWR sky130_fd_sc_hd__decap_4
X_450_ _067_ _068_ _069_ VGND VGND VPWR VPWR _070_ sky130_fd_sc_hd__nand3_1
XFILLER_0_37_15 VPWR VGND VPWR VGND sky130_ef_sc_hd__decap_12
X_648_ _261_ _262_ VGND VGND VPWR VPWR _263_ sky130_fd_sc_hd__nor2_1
X_717_ _328_ _329_ VGND VGND VPWR VPWR _330_ sky130_fd_sc_hd__nor2_1
X_579_ net2 net16 VGND VGND VPWR VPWR _196_ sky130_fd_sc_hd__and2_1
XFILLER_0_5_137 VPWR VGND VPWR VGND sky130_ef_sc_hd__decap_12
XFILLER_0_26_298 VGND VGND VPWR VPWR sky130_fd_sc_hd__fill_1
XFILLER_0_41_279 VGND VGND VPWR VPWR sky130_fd_sc_hd__fill_1
XTAP_132 VGND VPWR sky130_fd_sc_hd__tapvpwrvgnd_1
XTAP_121 VGND VPWR sky130_fd_sc_hd__tapvpwrvgnd_1
XTAP_110 VGND VPWR sky130_fd_sc_hd__tapvpwrvgnd_1
XTAP_143 VGND VPWR sky130_fd_sc_hd__tapvpwrvgnd_1
XTAP_154 VGND VPWR sky130_fd_sc_hd__tapvpwrvgnd_1
XTAP_165 VGND VPWR sky130_fd_sc_hd__tapvpwrvgnd_1
XTAP_176 VGND VPWR sky130_fd_sc_hd__tapvpwrvgnd_1
XTAP_187 VGND VPWR sky130_fd_sc_hd__tapvpwrvgnd_1
XTAP_198 VGND VPWR sky130_fd_sc_hd__tapvpwrvgnd_1
XFILLER_0_11_3 VPWR VGND VPWR VGND sky130_ef_sc_hd__decap_12
X_502_ _119_ _120_ VGND VGND VPWR VPWR _121_ sky130_fd_sc_hd__xnor2_1
XFILLER_0_23_279 VGND VGND VPWR VPWR sky130_fd_sc_hd__fill_1
Xrebuffer6 _113_ VGND VGND VPWR VPWR net39 sky130_fd_sc_hd__clkbuf_1
XFILLER_0_3_27 VPWR VGND VPWR VGND sky130_ef_sc_hd__decap_12
XFILLER_0_9_273 VGND VGND VPWR VPWR sky130_fd_sc_hd__decap_6
XFILLER_0_34_27 VGND VGND VPWR VPWR sky130_fd_sc_hd__fill_1
XFILLER_0_11_216 VGND VGND VPWR VPWR sky130_fd_sc_hd__fill_2
XFILLER_0_11_249 VPWR VGND VPWR VGND sky130_ef_sc_hd__decap_12
XFILLER_0_46_113 VPWR VGND VPWR VGND sky130_ef_sc_hd__decap_12
XFILLER_0_6_221 VPWR VGND VPWR VGND sky130_ef_sc_hd__decap_12
XFILLER_0_6_265 VPWR VGND VPWR VGND sky130_ef_sc_hd__decap_12
XFILLER_0_37_113 VGND VGND VPWR VPWR sky130_fd_sc_hd__decap_6
XFILLER_0_45_15 VPWR VGND VPWR VGND sky130_ef_sc_hd__decap_12
X_896_ clknet_2_3__leaf_clk _014_ _040_ VGND VGND VPWR VPWR net32 sky130_fd_sc_hd__dfrtp_1
XFILLER_0_43_105 VGND VGND VPWR VPWR sky130_fd_sc_hd__decap_6
XFILLER_0_43_149 VPWR VGND VPWR VGND sky130_ef_sc_hd__decap_12
XFILLER_0_3_279 VGND VGND VPWR VPWR sky130_fd_sc_hd__fill_1
XFILLER_0_34_127 VPWR VGND VPWR VGND sky130_ef_sc_hd__decap_12
XFILLER_0_19_124 VGND VGND VPWR VPWR sky130_fd_sc_hd__fill_2
X_681_ _292_ _294_ VGND VGND VPWR VPWR _295_ sky130_fd_sc_hd__xor2_1
X_750_ _344_ _312_ _334_ _336_ VGND VGND VPWR VPWR _361_ sky130_fd_sc_hd__o22a_1
X_879_ _443_ VGND VGND VPWR VPWR _055_ sky130_fd_sc_hd__inv_2
XFILLER_0_41_3 VPWR VGND VPWR VGND sky130_ef_sc_hd__decap_12
XFILLER_0_1_93 VPWR VGND VPWR VGND sky130_ef_sc_hd__decap_12
XFILLER_0_22_119 VGND VGND VPWR VPWR sky130_fd_sc_hd__decap_4
XFILLER_0_30_130 VGND VGND VPWR VPWR sky130_fd_sc_hd__decap_4
X_802_ mult_reg\[7\] net31 VGND VGND VPWR VPWR _403_ sky130_fd_sc_hd__nor2_1
XFILLER_0_30_141 VGND VGND VPWR VPWR sky130_fd_sc_hd__fill_1
XFILLER_0_30_174 VGND VGND VPWR VPWR sky130_fd_sc_hd__decap_8
X_664_ _277_ _278_ VGND VGND VPWR VPWR _031_ sky130_fd_sc_hd__xnor2_1
X_733_ _344_ _291_ _316_ _318_ VGND VGND VPWR VPWR _345_ sky130_fd_sc_hd__o22ai_2
X_595_ _178_ _179_ _210_ VGND VGND VPWR VPWR _212_ sky130_fd_sc_hd__nand3_1
XFILLER_0_42_27 VGND VGND VPWR VPWR sky130_fd_sc_hd__fill_1
XTAP_314 VGND VPWR sky130_fd_sc_hd__tapvpwrvgnd_1
XTAP_303 VGND VPWR sky130_fd_sc_hd__tapvpwrvgnd_1
XFILLER_0_6_27 VGND VGND VPWR VPWR sky130_fd_sc_hd__fill_1
XTAP_336 VGND VPWR sky130_fd_sc_hd__tapvpwrvgnd_1
XTAP_325 VGND VPWR sky130_fd_sc_hd__tapvpwrvgnd_1
XFILLER_0_16_83 VGND VGND VPWR VPWR sky130_fd_sc_hd__fill_1
XFILLER_0_44_277 VPWR VGND VPWR VGND sky130_ef_sc_hd__decap_12
XFILLER_0_44_233 VPWR VGND VPWR VGND sky130_ef_sc_hd__decap_12
XFILLER_0_8_168 VPWR VGND VPWR VGND sky130_ef_sc_hd__decap_12
XFILLER_0_12_141 VGND VGND VPWR VPWR sky130_fd_sc_hd__decap_6
XFILLER_0_35_266 VPWR VGND VPWR VGND sky130_ef_sc_hd__decap_12
Xoutput30 net30 VGND VGND VPWR VPWR accumulator[6] sky130_fd_sc_hd__clkbuf_4
XFILLER_0_37_27 VPWR VGND VPWR VGND sky130_ef_sc_hd__decap_12
X_716_ _300_ _309_ _327_ VGND VGND VPWR VPWR _329_ sky130_fd_sc_hd__o21a_1
X_647_ _085_ _086_ net16 net17 VGND VGND VPWR VPWR _262_ sky130_fd_sc_hd__and4_1
X_578_ _072_ _116_ _157_ _158_ VGND VGND VPWR VPWR _195_ sky130_fd_sc_hd__and4_1
XFILLER_0_41_225 VPWR VGND VPWR VGND sky130_ef_sc_hd__decap_12
XFILLER_0_5_149 VPWR VGND VPWR VGND sky130_ef_sc_hd__decap_12
XFILLER_0_5_105 VGND VGND VPWR VPWR sky130_fd_sc_hd__decap_6
XTAP_144 VGND VPWR sky130_fd_sc_hd__tapvpwrvgnd_1
XTAP_133 VGND VPWR sky130_fd_sc_hd__tapvpwrvgnd_1
XTAP_122 VGND VPWR sky130_fd_sc_hd__tapvpwrvgnd_1
XTAP_111 VGND VPWR sky130_fd_sc_hd__tapvpwrvgnd_1
XTAP_100 VGND VPWR sky130_fd_sc_hd__tapvpwrvgnd_1
XTAP_155 VGND VPWR sky130_fd_sc_hd__tapvpwrvgnd_1
XTAP_166 VGND VPWR sky130_fd_sc_hd__tapvpwrvgnd_1
.ends
